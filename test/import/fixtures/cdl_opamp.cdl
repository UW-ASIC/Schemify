*.PININFO VIN+ VIN- VOUT VDD! VSS!
.SUBCKT opamp VIN+ VIN- VOUT VDD! VSS!
*.PININFO VIN+:I VIN-:I VOUT:O VDD!:B VSS!:B
M0 net1 VIN+ tail VSS! nmos w=2e-6 l=500e-9 m=1
M1 net2 VIN- tail VSS! nmos w=2e-6 l=500e-9 m=1
M2 net1 net1 VDD! VDD! pmos w=4e-6 l=500e-9 m=1
M3 net2 net1 VDD! VDD! pmos w=4e-6 l=500e-9 m=1
M4 tail nbias VSS! VSS! nmos w=4e-6 l=1e-6 m=1
M5 VOUT net2 VDD! VDD! pmos w=10e-6 l=500e-9 m=1
M6 VOUT nbias2 VSS! VSS! nmos w=4e-6 l=500e-9 m=1
C0 net2 VOUT cap c=1e-12
.ENDS opamp
