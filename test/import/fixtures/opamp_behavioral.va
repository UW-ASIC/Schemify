`include "constants.vams"
`include "disciplines.vams"

// Simple behavioral opamp model
module opamp_behavioral(out, inp, inn, vdd, vss);
    output out;
    input inp, inn;
    inout vdd, vss;
    electrical out, inp, inn, vdd, vss;

    parameter real gain = 1000.0;
    parameter real bandwidth = 1e6;
    parameter real vos = 0.0;
    parameter real rin = 1e12;
    parameter real rout = 100.0;

    real vdiff;

    analog begin
        vdiff = V(inp) - V(inn) - vos;
        I(inp, inn) <+ vdiff / rin;
        V(out) <+ laplace_nd(gain * vdiff, {1}, {1, 1.0/(6.28*bandwidth)});
        I(out) <+ V(out) / rout;
    end
endmodule
