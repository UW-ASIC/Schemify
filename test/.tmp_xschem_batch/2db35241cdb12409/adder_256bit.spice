** sch_path: /home/omare/Documents/UWASIC/Schemify/test/examples/xschem_sky130/sky130_tests/adder_256bit.sch
.subckt adder_256bit A[255] A[254] A[253] A[252] A[251] A[250] A[249] A[248] A[247] A[246] A[245] A[244] A[243] A[242] A[241]
+ A[240] A[239] A[238] A[237] A[236] A[235] A[234] A[233] A[232] A[231] A[230] A[229] A[228] A[227] A[226] A[225] A[224] A[223] A[222]
+ A[221] A[220] A[219] A[218] A[217] A[216] A[215] A[214] A[213] A[212] A[211] A[210] A[209] A[208] A[207] A[206] A[205] A[204] A[203]
+ A[202] A[201] A[200] A[199] A[198] A[197] A[196] A[195] A[194] A[193] A[192] A[191] A[190] A[189] A[188] A[187] A[186] A[185] A[184]
+ A[183] A[182] A[181] A[180] A[179] A[178] A[177] A[176] A[175] A[174] A[173] A[172] A[171] A[170] A[169] A[168] A[167] A[166] A[165]
+ A[164] A[163] A[162] A[161] A[160] A[159] A[158] A[157] A[156] A[155] A[154] A[153] A[152] A[151] A[150] A[149] A[148] A[147] A[146]
+ A[145] A[144] A[143] A[142] A[141] A[140] A[139] A[138] A[137] A[136] A[135] A[134] A[133] A[132] A[131] A[130] A[129] A[128] A[127]
+ A[126] A[125] A[124] A[123] A[122] A[121] A[120] A[119] A[118] A[117] A[116] A[115] A[114] A[113] A[112] A[111] A[110] A[109] A[108]
+ A[107] A[106] A[105] A[104] A[103] A[102] A[101] A[100] A[99] A[98] A[97] A[96] A[95] A[94] A[93] A[92] A[91] A[90] A[89] A[88] A[87]
+ A[86] A[85] A[84] A[83] A[82] A[81] A[80] A[79] A[78] A[77] A[76] A[75] A[74] A[73] A[72] A[71] A[70] A[69] A[68] A[67] A[66] A[65]
+ A[64] A[63] A[62] A[61] A[60] A[59] A[58] A[57] A[56] A[55] A[54] A[53] A[52] A[51] A[50] A[49] A[48] A[47] A[46] A[45] A[44] A[43]
+ A[42] A[41] A[40] A[39] A[38] A[37] A[36] A[35] A[34] A[33] A[32] A[31] A[30] A[29] A[28] A[27] A[26] A[25] A[24] A[23] A[22] A[21]
+ A[20] A[19] A[18] A[17] A[16] A[15] A[14] A[13] A[12] A[11] A[10] A[9] A[8] A[7] A[6] A[5] A[4] A[3] A[2] A[1] A[0] S[255] S[254]
+ S[253] S[252] S[251] S[250] S[249] S[248] S[247] S[246] S[245] S[244] S[243] S[242] S[241] S[240] S[239] S[238] S[237] S[236] S[235]
+ S[234] S[233] S[232] S[231] S[230] S[229] S[228] S[227] S[226] S[225] S[224] S[223] S[222] S[221] S[220] S[219] S[218] S[217] S[216]
+ S[215] S[214] S[213] S[212] S[211] S[210] S[209] S[208] S[207] S[206] S[205] S[204] S[203] S[202] S[201] S[200] S[199] S[198] S[197]
+ S[196] S[195] S[194] S[193] S[192] S[191] S[190] S[189] S[188] S[187] S[186] S[185] S[184] S[183] S[182] S[181] S[180] S[179] S[178]
+ S[177] S[176] S[175] S[174] S[173] S[172] S[171] S[170] S[169] S[168] S[167] S[166] S[165] S[164] S[163] S[162] S[161] S[160] S[159]
+ S[158] S[157] S[156] S[155] S[154] S[153] S[152] S[151] S[150] S[149] S[148] S[147] S[146] S[145] S[144] S[143] S[142] S[141] S[140]
+ S[139] S[138] S[137] S[136] S[135] S[134] S[133] S[132] S[131] S[130] S[129] S[128] S[127] S[126] S[125] S[124] S[123] S[122] S[121]
+ S[120] S[119] S[118] S[117] S[116] S[115] S[114] S[113] S[112] S[111] S[110] S[109] S[108] S[107] S[106] S[105] S[104] S[103] S[102]
+ S[101] S[100] S[99] S[98] S[97] S[96] S[95] S[94] S[93] S[92] S[91] S[90] S[89] S[88] S[87] S[86] S[85] S[84] S[83] S[82] S[81] S[80]
+ S[79] S[78] S[77] S[76] S[75] S[74] S[73] S[72] S[71] S[70] S[69] S[68] S[67] S[66] S[65] S[64] S[63] S[62] S[61] S[60] S[59] S[58]
+ S[57] S[56] S[55] S[54] S[53] S[52] S[51] S[50] S[49] S[48] S[47] S[46] S[45] S[44] S[43] S[42] S[41] S[40] S[39] S[38] S[37] S[36]
+ S[35] S[34] S[33] S[32] S[31] S[30] S[29] S[28] S[27] S[26] S[25] S[24] S[23] S[22] S[21] S[20] S[19] S[18] S[17] S[16] S[15] S[14]
+ S[13] S[12] S[11] S[10] S[9] S[8] S[7] S[6] S[5] S[4] S[3] S[2] S[1] S[0] B[255] B[254] B[253] B[252] B[251] B[250] B[249] B[248]
+ B[247] B[246] B[245] B[244] B[243] B[242] B[241] B[240] B[239] B[238] B[237] B[236] B[235] B[234] B[233] B[232] B[231] B[230] B[229]
+ B[228] B[227] B[226] B[225] B[224] B[223] B[222] B[221] B[220] B[219] B[218] B[217] B[216] B[215] B[214] B[213] B[212] B[211] B[210]
+ B[209] B[208] B[207] B[206] B[205] B[204] B[203] B[202] B[201] B[200] B[199] B[198] B[197] B[196] B[195] B[194] B[193] B[192] B[191]
+ B[190] B[189] B[188] B[187] B[186] B[185] B[184] B[183] B[182] B[181] B[180] B[179] B[178] B[177] B[176] B[175] B[174] B[173] B[172]
+ B[171] B[170] B[169] B[168] B[167] B[166] B[165] B[164] B[163] B[162] B[161] B[160] B[159] B[158] B[157] B[156] B[155] B[154] B[153]
+ B[152] B[151] B[150] B[149] B[148] B[147] B[146] B[145] B[144] B[143] B[142] B[141] B[140] B[139] B[138] B[137] B[136] B[135] B[134]
+ B[133] B[132] B[131] B[130] B[129] B[128] B[127] B[126] B[125] B[124] B[123] B[122] B[121] B[120] B[119] B[118] B[117] B[116] B[115]
+ B[114] B[113] B[112] B[111] B[110] B[109] B[108] B[107] B[106] B[105] B[104] B[103] B[102] B[101] B[100] B[99] B[98] B[97] B[96] B[95]
+ B[94] B[93] B[92] B[91] B[90] B[89] B[88] B[87] B[86] B[85] B[84] B[83] B[82] B[81] B[80] B[79] B[78] B[77] B[76] B[75] B[74] B[73]
+ B[72] B[71] B[70] B[69] B[68] B[67] B[66] B[65] B[64] B[63] B[62] B[61] B[60] B[59] B[58] B[57] B[56] B[55] B[54] B[53] B[52] B[51]
+ B[50] B[49] B[48] B[47] B[46] B[45] B[44] B[43] B[42] B[41] B[40] B[39] B[38] B[37] B[36] B[35] B[34] B[33] B[32] B[31] B[30] B[29]
+ B[28] B[27] B[26] B[25] B[24] B[23] B[22] B[21] B[20] B[19] B[18] B[17] B[16] B[15] B[14] B[13] B[12] B[11] B[10] B[9] B[8] B[7] B[6]
+ B[5] B[4] B[3] B[2] B[1] B[0] COUT SG CIN SP

*  p1 -  ipin  IS MISSING !!!!
*  p2 -  ipin  IS MISSING !!!!
*  p3 -  ipin  IS MISSING !!!!
*  p4 -  opin  IS MISSING !!!!
*  p5 -  opin  IS MISSING !!!!
*  l2 -  title  IS MISSING !!!!
*  xadd64[3],xadd64[2],xadd64[1],xadd64[0] -  adder_64bit  IS MISSING !!!!
*  p6 -  lab_pin  IS MISSING !!!!
*  p9 -  lab_pin  IS MISSING !!!!
*  p10 -  lab_pin  IS MISSING !!!!
*  p11 -  lab_pin  IS MISSING !!!!
*  p12 -  lab_pin  IS MISSING !!!!
*  p13 -  lab_pin  IS MISSING !!!!
*  xcla -  cla_4bits  IS MISSING !!!!
*  p14 -  lab_pin  IS MISSING !!!!
*  p15 -  lab_pin  IS MISSING !!!!
*  p16 -  lab_pin  IS MISSING !!!!
*  p17 -  lab_pin  IS MISSING !!!!
*  p18 -  lab_pin  IS MISSING !!!!
*  p19 -  lab_pin  IS MISSING !!!!
*  p20 -  lab_pin  IS MISSING !!!!
*  p21 -  lab_pin  IS MISSING !!!!
*  p22 -  lab_pin  IS MISSING !!!!
*  p7 -  opin  IS MISSING !!!!
*  p8 -  opin  IS MISSING !!!!
*  l1 -  noconn  IS MISSING !!!!
.ends
