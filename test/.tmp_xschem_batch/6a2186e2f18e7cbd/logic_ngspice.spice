** sch_path: /home/omare/Documents/UWASIC/Schemify/test/examples/xschem_sky130/sky130_tests/logic_ngspice.sch
.subckt logic_ngspice

*  l1 -  title  IS MISSING !!!!
*  x1 -  lvnand  IS MISSING !!!!
*  l2 -  lab_wire  IS MISSING !!!!
*  l3 -  lab_wire  IS MISSING !!!!
*  l4 -  lab_pin  IS MISSING !!!!
*  l5 -  lab_pin  IS MISSING !!!!
*  V1 -  vsource  IS MISSING !!!!
*  l6 -  lab_pin  IS MISSING !!!!
*  l7 -  lab_pin  IS MISSING !!!!
*  V2 -  vsource  IS MISSING !!!!
*  l8 -  lab_pin  IS MISSING !!!!
*  l9 -  lab_pin  IS MISSING !!!!
*  V3 -  vsource  IS MISSING !!!!
*  l10 -  lab_pin  IS MISSING !!!!
*  l11 -  lab_pin  IS MISSING !!!!
*  x3 -  not  IS MISSING !!!!
*  NGSPICE -  code  IS MISSING !!!!
?
*  V4 -  vsource  IS MISSING !!!!
*  l12 -  lab_pin  IS MISSING !!!!
*  l13 -  lab_pin  IS MISSING !!!!
*  h1 -  launcher  IS MISSING !!!!
.ends
