** sch_path: /home/omare/Documents/UWASIC/Schemify/test/examples/xschem_sky130/sky130_tests/cmos_ac_sweep.sch
.subckt cmos_ac_sweep

*  p20 -  lab_pin  IS MISSING !!!!
*  p17 -  lab_pin  IS MISSING !!!!
*  l1 -  title  IS MISSING !!!!
*  VVCC -  vsource  IS MISSING !!!!
*  p1 -  lab_pin  IS MISSING !!!!
*  p2 -  lab_pin  IS MISSING !!!!
*  p3 -  lab_pin  IS MISSING !!!!
*  IBIAS -  isource  IS MISSING !!!!
*  p4 -  lab_pin  IS MISSING !!!!
*  p5 -  lab_pin  IS MISSING !!!!
*  p0 -  lab_pin  IS MISSING !!!!
*  p8 -  lab_pin  IS MISSING !!!!
*  p9 -  lab_pin  IS MISSING !!!!
*  p10 -  lab_pin  IS MISSING !!!!
*  p11 -  lab_pin  IS MISSING !!!!
*  p13 -  lab_pin  IS MISSING !!!!
*  p15 -  lab_pin  IS MISSING !!!!
*  p18 -  lab_pin  IS MISSING !!!!
*  CL -  capa  IS MISSING !!!!
*  p12 -  lab_pin  IS MISSING !!!!
*  h1 -  launcher  IS MISSING !!!!
*  h2 -  launcher  IS MISSING !!!!
*  r3 -  ngspice_probe  IS MISSING !!!!
*  h3 -  launcher  IS MISSING !!!!
*  Vright -  ammeter  IS MISSING !!!!
*  V3 -  vsource  IS MISSING !!!!
*  p19 -  lab_pin  IS MISSING !!!!
*  V2 -  vsource  IS MISSING !!!!
*  COMMANDS -  code_shown  IS MISSING !!!!
*  M7 -  pfet_01v8_lvt  IS MISSING !!!!
*  M2 -  pfet_01v8_lvt  IS MISSING !!!!
*  M6 -  nfet_01v8  IS MISSING !!!!
*  M4 -  nfet_01v8  IS MISSING !!!!
*  M1 -  nfet_01v8  IS MISSING !!!!
*  M3 -  nfet_01v8  IS MISSING !!!!
?
*  Vtail -  ammeter  IS MISSING !!!!
*  Vleft -  ammeter  IS MISSING !!!!
*  h4 -  launcher  IS MISSING !!!!
*  annot1 -  annotate_fet_params  IS MISSING !!!!
*  annot2 -  annotate_fet_params  IS MISSING !!!!
*  annot3 -  annotate_fet_params  IS MISSING !!!!
*  annot4 -  annotate_fet_params  IS MISSING !!!!
.ends
