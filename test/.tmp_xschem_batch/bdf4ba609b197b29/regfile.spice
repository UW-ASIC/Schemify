** sch_path: /home/omare/Documents/UWASIC/Schemify/test/examples/xschem_sky130/mips_cpu/regfile.sch
.subckt regfile clk addr1[4] addr1[3] addr1[2] addr1[1] addr1[0] addr2[4] addr2[3] addr2[2] addr2[1] addr2[0] data1[31] data1[30]
+ data1[29] data1[28] data1[27] data1[26] data1[25] data1[24] data1[23] data1[22] data1[21] data1[20] data1[19] data1[18] data1[17] data1[16]
+ data1[15] data1[14] data1[13] data1[12] data1[11] data1[10] data1[9] data1[8] data1[7] data1[6] data1[5] data1[4] data1[3] data1[2]
+ data1[1] data1[0] rw data2[31] data2[30] data2[29] data2[28] data2[27] data2[26] data2[25] data2[24] data2[23] data2[22] data2[21]
+ data2[20] data2[19] data2[18] data2[17] data2[16] data2[15] data2[14] data2[13] data2[12] data2[11] data2[10] data2[9] data2[8] data2[7]
+ data2[6] data2[5] data2[4] data2[3] data2[2] data2[1] data2[0] addr3[4] addr3[3] addr3[2] addr3[1] addr3[0] wdata[31] wdata[30] wdata[29]
+ wdata[28] wdata[27] wdata[26] wdata[25] wdata[24] wdata[23] wdata[22] wdata[21] wdata[20] wdata[19] wdata[18] wdata[17] wdata[16] wdata[15]
+ wdata[14] wdata[13] wdata[12] wdata[11] wdata[10] wdata[9] wdata[8] wdata[7] wdata[6] wdata[5] wdata[4] wdata[3] wdata[2] wdata[1] wdata[0]

*  l1 -  title  IS MISSING !!!!
*  p2 -  ipin  IS MISSING !!!!
*  p3 -  ipin  IS MISSING !!!!
*  p5 -  ipin  IS MISSING !!!!
*  p6 -  opin  IS MISSING !!!!
*  p7 -  opin  IS MISSING !!!!
*  p8 -  ipin  IS MISSING !!!!
*  p4 -  ipin  IS MISSING !!!!
*  p1 -  ipin  IS MISSING !!!!
*  x1 -    IS MISSING !!!!
*  l3 -  noconn  IS MISSING !!!!
*  l4 -  noconn  IS MISSING !!!!
*  l5 -  noconn  IS MISSING !!!!
*  l6 -  noconn  IS MISSING !!!!
*  l2 -  noconn  IS MISSING !!!!
*  l7 -  noconn  IS MISSING !!!!
*  l8 -  noconn  IS MISSING !!!!
*  l9 -  noconn  IS MISSING !!!!
.ends
