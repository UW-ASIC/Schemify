** sch_path: /home/omare/Documents/UWASIC/Schemify/test/examples/xschem_sky130/sky130_tests/cla_4bits.sch
.subckt cla_4bits SG SP C1 P[3] P[2] P[1] P[0] C2 G[3] G[2] G[1] G[0] C3 C4 C0

*  p1 -  ipin  IS MISSING !!!!
*  p2 -  ipin  IS MISSING !!!!
*  p3 -  ipin  IS MISSING !!!!
*  l2 -  title  IS MISSING !!!!
*  p4 -  opin  IS MISSING !!!!
*  p5 -  opin  IS MISSING !!!!
*  p7 -  opin  IS MISSING !!!!
*  p9 -  opin  IS MISSING !!!!
*  p58 -  opin  IS MISSING !!!!
*  p59 -  opin  IS MISSING !!!!
*  p0 -  lab_pin  IS MISSING !!!!
*  p6 -  lab_pin  IS MISSING !!!!
*  p8 -  lab_pin  IS MISSING !!!!
*  p10 -  lab_pin  IS MISSING !!!!
*  p11 -  lab_pin  IS MISSING !!!!
*  p12 -  lab_pin  IS MISSING !!!!
*  p13 -  lab_pin  IS MISSING !!!!
*  p14 -  lab_pin  IS MISSING !!!!
*  p15 -  lab_pin  IS MISSING !!!!
*  p16 -  lab_pin  IS MISSING !!!!
*  p17 -  lab_pin  IS MISSING !!!!
*  p18 -  lab_pin  IS MISSING !!!!
*  p19 -  lab_pin  IS MISSING !!!!
*  p20 -  lab_pin  IS MISSING !!!!
*  p21 -  lab_pin  IS MISSING !!!!
*  p22 -  lab_pin  IS MISSING !!!!
*  p23 -  lab_pin  IS MISSING !!!!
*  p24 -  lab_pin  IS MISSING !!!!
*  p25 -  lab_pin  IS MISSING !!!!
*  p26 -  lab_pin  IS MISSING !!!!
*  p27 -  lab_pin  IS MISSING !!!!
*  p28 -  lab_pin  IS MISSING !!!!
*  p29 -  lab_pin  IS MISSING !!!!
*  p30 -  lab_pin  IS MISSING !!!!
*  p31 -  lab_pin  IS MISSING !!!!
*  p32 -  lab_pin  IS MISSING !!!!
*  p33 -  lab_pin  IS MISSING !!!!
*  p34 -  lab_pin  IS MISSING !!!!
*  p35 -  lab_pin  IS MISSING !!!!
*  p36 -  lab_pin  IS MISSING !!!!
*  p37 -  lab_pin  IS MISSING !!!!
*  p38 -  lab_pin  IS MISSING !!!!
*  p39 -  lab_pin  IS MISSING !!!!
*  p40 -  lab_pin  IS MISSING !!!!
*  p41 -  lab_pin  IS MISSING !!!!
*  p42 -  lab_pin  IS MISSING !!!!
*  p43 -  lab_pin  IS MISSING !!!!
*  p44 -  lab_pin  IS MISSING !!!!
*  p45 -  lab_pin  IS MISSING !!!!
*  p46 -  lab_pin  IS MISSING !!!!
*  p47 -  lab_pin  IS MISSING !!!!
*  p48 -  lab_pin  IS MISSING !!!!
*  p49 -  lab_pin  IS MISSING !!!!
*  p50 -  lab_pin  IS MISSING !!!!
*  p51 -  lab_pin  IS MISSING !!!!
*  p52 -  lab_pin  IS MISSING !!!!
*  p53 -  lab_pin  IS MISSING !!!!
*  p54 -  lab_pin  IS MISSING !!!!
*  p55 -  lab_pin  IS MISSING !!!!
*  x1 -  inv_1  IS MISSING !!!!
*  x2 -  inv_1  IS MISSING !!!!
*  x3 -  inv_1  IS MISSING !!!!
*  x4 -  inv_1  IS MISSING !!!!
*  x5 -  inv_1  IS MISSING !!!!
*  x6 -  inv_1  IS MISSING !!!!
*  x7 -  a21oi_1  IS MISSING !!!!
*  x8 -  a21oi_1  IS MISSING !!!!
*  x9 -  a21oi_1  IS MISSING !!!!
*  x10 -  a21oi_1  IS MISSING !!!!
*  x11 -  inv_1  IS MISSING !!!!
*  x12 -  o21ai_1  IS MISSING !!!!
*  x13 -  o21ai_1  IS MISSING !!!!
*  x14 -  o21ai_1  IS MISSING !!!!
*  x15 -  nor2_1  IS MISSING !!!!
*  x16 -  nand3_1  IS MISSING !!!!
*  C2 -  parax_cap  IS MISSING !!!!
*  C1 -  parax_cap  IS MISSING !!!!
*  C3 -  parax_cap  IS MISSING !!!!
*  C4 -  parax_cap  IS MISSING !!!!
*  C5 -  parax_cap  IS MISSING !!!!
*  C6 -  parax_cap  IS MISSING !!!!
*  C7 -  parax_cap  IS MISSING !!!!
*  C8 -  parax_cap  IS MISSING !!!!
*  C9 -  parax_cap  IS MISSING !!!!
*  C10 -  parax_cap  IS MISSING !!!!
*  C19[3],C19[2],C19[1],C19[0] -  parax_cap  IS MISSING !!!!
*  C18[3],C18[2],C18[1],C18[0] -  parax_cap  IS MISSING !!!!
*  C17 -  parax_cap  IS MISSING !!!!
.ends
