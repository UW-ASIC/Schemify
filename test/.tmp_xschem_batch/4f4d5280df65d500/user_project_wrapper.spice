** sch_path: /home/omare/Documents/UWASIC/Schemify/test/examples/xschem_sky130/decred_hash_macro/user_project_wrapper.sch
.subckt user_project_wrapper

*  p41 -  lab_pin  IS MISSING !!!!
*  p42 -  lab_pin  IS MISSING !!!!
*  p43 -  lab_pin  IS MISSING !!!!
*  p44 -  lab_pin  IS MISSING !!!!
*  p45 -  lab_pin  IS MISSING !!!!
*  p46 -  lab_pin  IS MISSING !!!!
*  p47 -  lab_pin  IS MISSING !!!!
*  p48 -  lab_pin  IS MISSING !!!!
*  p49 -  lab_pin  IS MISSING !!!!
*  Xdecred_hash_block0 -  decred_hash_macro  IS MISSING !!!!
*  p50 -  lab_pin  IS MISSING !!!!
*  p52 -  lab_pin  IS MISSING !!!!
*  p53 -  lab_pin  IS MISSING !!!!
*  p54 -  lab_pin  IS MISSING !!!!
*  p55 -  lab_pin  IS MISSING !!!!
*  p57 -  lab_pin  IS MISSING !!!!
*  p58 -  lab_pin  IS MISSING !!!!
*  Xdecred_hash_block1 -  decred_hash_macro  IS MISSING !!!!
*  p59 -  lab_pin  IS MISSING !!!!
*  p61 -  lab_pin  IS MISSING !!!!
*  p62 -  lab_pin  IS MISSING !!!!
*  p63 -  lab_pin  IS MISSING !!!!
*  p64 -  lab_pin  IS MISSING !!!!
*  p66 -  lab_pin  IS MISSING !!!!
*  p67 -  lab_pin  IS MISSING !!!!
*  Xdecred_hash_block2 -  decred_hash_macro  IS MISSING !!!!
*  p68 -  lab_pin  IS MISSING !!!!
*  p70 -  lab_pin  IS MISSING !!!!
*  p71 -  lab_pin  IS MISSING !!!!
*  p72 -  lab_pin  IS MISSING !!!!
*  p73 -  lab_pin  IS MISSING !!!!
*  p75 -  lab_pin  IS MISSING !!!!
*  p76 -  lab_pin  IS MISSING !!!!
*  Xdecred_hash_block3 -  decred_hash_macro  IS MISSING !!!!
*  p77 -  lab_pin  IS MISSING !!!!
*  p78 -  lab_pin  IS MISSING !!!!
*  p79 -  lab_pin  IS MISSING !!!!
*  p80 -  lab_pin  IS MISSING !!!!
*  p81 -  lab_pin  IS MISSING !!!!
*  p82 -  lab_pin  IS MISSING !!!!
*  p83 -  lab_pin  IS MISSING !!!!
*  p84 -  lab_pin  IS MISSING !!!!
*  p85 -  lab_pin  IS MISSING !!!!
*  p86 -  lab_pin  IS MISSING !!!!
*  p87 -  lab_pin  IS MISSING !!!!
*  p88 -  lab_pin  IS MISSING !!!!
*  p89 -  lab_pin  IS MISSING !!!!
*  p90 -  lab_pin  IS MISSING !!!!
*  p91 -  lab_pin  IS MISSING !!!!
*  p92 -  lab_pin  IS MISSING !!!!
*  p93 -  lab_pin  IS MISSING !!!!
*  p94 -  lab_pin  IS MISSING !!!!
*  p95 -  lab_pin  IS MISSING !!!!
*  p96 -  lab_pin  IS MISSING !!!!
*  p97 -  lab_pin  IS MISSING !!!!
*  p98 -  lab_pin  IS MISSING !!!!
*  p99 -  lab_pin  IS MISSING !!!!
*  p100 -  lab_pin  IS MISSING !!!!
*  p101 -  lab_pin  IS MISSING !!!!
*  p102 -  lab_pin  IS MISSING !!!!
*  p103 -  lab_pin  IS MISSING !!!!
*  p104 -  lab_pin  IS MISSING !!!!
*  p105 -  lab_pin  IS MISSING !!!!
*  p106 -  lab_pin  IS MISSING !!!!
*  p107 -  lab_pin  IS MISSING !!!!
*  p108 -  lab_pin  IS MISSING !!!!
*  Xdecred_controller_block -  decred_controller  IS MISSING !!!!
*  l1 -  title  IS MISSING !!!!
*  p1 -  lab_pin  IS MISSING !!!!
*  p2 -  lab_pin  IS MISSING !!!!
*  p3 -  lab_pin  IS MISSING !!!!
*  p4 -  lab_pin  IS MISSING !!!!
*  p5 -  lab_pin  IS MISSING !!!!
*  p6 -  lab_pin  IS MISSING !!!!
*  p109 -  iopin  IS MISSING !!!!
*  p110 -  ipin  IS MISSING !!!!
*  p111 -  opin  IS MISSING !!!!
*  p112 -  opin  IS MISSING !!!!
*  p113 -  ipin  IS MISSING !!!!
*  p114 -  opin  IS MISSING !!!!
*  p115 -  ipin  IS MISSING !!!!
*  p117 -  ipin  IS MISSING !!!!
*  p118 -  ipin  IS MISSING !!!!
*  p119 -  ipin  IS MISSING !!!!
*  p120 -  opin  IS MISSING !!!!
*  p121 -  ipin  IS MISSING !!!!
*  p122 -  ipin  IS MISSING !!!!
*  p123 -  ipin  IS MISSING !!!!
*  p124 -  opin  IS MISSING !!!!
*  p125 -  ipin  IS MISSING !!!!
*  p126 -  ipin  IS MISSING !!!!
*  p127 -  ipin  IS MISSING !!!!
*  p129 -  iopin  IS MISSING !!!!
*  p130 -  iopin  IS MISSING !!!!
*  p131 -  iopin  IS MISSING !!!!
*  p132 -  iopin  IS MISSING !!!!
*  p133 -  iopin  IS MISSING !!!!
*  p134 -  iopin  IS MISSING !!!!
*  p135 -  iopin  IS MISSING !!!!
*  p136 -  iopin  IS MISSING !!!!
.ends
