** sch_path: /home/omare/Documents/UWASIC/Schemify/test/examples/xschem_sky130/sky130_tests/tb_charge_pump.sch
.subckt tb_charge_pump

*  x1 -  charge_pump  IS MISSING !!!!
*  x2 -  charge_pump_phasegen  IS MISSING !!!!
*  V1 -  vsource  IS MISSING !!!!
*  p9 -  lab_pin  IS MISSING !!!!
*  V2 -  vsource  IS MISSING !!!!
*  p1 -  lab_pin  IS MISSING !!!!
*  p2 -  lab_pin  IS MISSING !!!!
*  p3 -  lab_wire  IS MISSING !!!!
*  p4 -  lab_wire  IS MISSING !!!!
*  p5 -  lab_wire  IS MISSING !!!!
*  p6 -  lab_pin  IS MISSING !!!!
*  p7 -  lab_wire  IS MISSING !!!!
*  p8 -  lab_pin  IS MISSING !!!!
*  C1 -  capa  IS MISSING !!!!
*  p15 -  lab_pin  IS MISSING !!!!
?
*  l2 -  title  IS MISSING !!!!
*  STIMULI -  code_shown  IS MISSING !!!!
*  h5 -  launcher  IS MISSING !!!!
*  I0 -  isource  IS MISSING !!!!
*  p10 -  lab_pin  IS MISSING !!!!
*  Vload -  ammeter  IS MISSING !!!!
*  x3 -  charge_pump2  IS MISSING !!!!
*  V3 -  vsource  IS MISSING !!!!
*  p11 -  lab_pin  IS MISSING !!!!
*  p12 -  lab_pin  IS MISSING !!!!
*  p14 -  lab_pin  IS MISSING !!!!
*  p16 -  lab_pin  IS MISSING !!!!
*  p13 -  lab_pin  IS MISSING !!!!
*  C2 -  capa  IS MISSING !!!!
*  p17 -  lab_pin  IS MISSING !!!!
*  I1 -  isource  IS MISSING !!!!
*  p18 -  lab_pin  IS MISSING !!!!
*  Vload1 -  ammeter  IS MISSING !!!!
*  l3 -  noconn  IS MISSING !!!!
*  C3 -  capa  IS MISSING !!!!
*  p19 -  lab_pin  IS MISSING !!!!
*  p20 -  lab_pin  IS MISSING !!!!
*  Vload2 -  ammeter  IS MISSING !!!!
*  p21 -  lab_pin  IS MISSING !!!!
*  x7 -  charge_pump_ideal  IS MISSING !!!!
*  p22 -  lab_pin  IS MISSING !!!!
*  p23 -  lab_pin  IS MISSING !!!!
*  I2 -  isource  IS MISSING !!!!
*  V4 -  vsource  IS MISSING !!!!
*  R1 -  res  IS MISSING !!!!
*  p24 -  lab_pin  IS MISSING !!!!
*  p25 -  lab_pin  IS MISSING !!!!
*  C4 -  capa  IS MISSING !!!!
*  p26 -  lab_pin  IS MISSING !!!!
*  p27 -  lab_pin  IS MISSING !!!!
*  Vload3 -  ammeter  IS MISSING !!!!
*  I3 -  isource  IS MISSING !!!!
*  p28 -  lab_pin  IS MISSING !!!!
*  p29 -  lab_pin  IS MISSING !!!!
*  p30 -  lab_pin  IS MISSING !!!!
*  p31 -  lab_pin  IS MISSING !!!!
*  p32 -  lab_pin  IS MISSING !!!!
.ends
