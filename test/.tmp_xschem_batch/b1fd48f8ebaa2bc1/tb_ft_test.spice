** sch_path: /home/omare/Documents/UWASIC/Schemify/test/examples/xschem_sky130/sky130_tests/tb_ft_test.sch
.subckt tb_ft_test

*  M_DUT -  nfet3_01v8_lvt  IS MISSING !!!!
*  Idref -  isource  IS MISSING !!!!
*  l1 -  gnd  IS MISSING !!!!
*  SIMULATION -  code  IS MISSING !!!!
*  l3 -  lab_wire  IS MISSING !!!!
*  l4 -  title  IS MISSING !!!!
*  h4 -  launcher  IS MISSING !!!!
*  annot1 -  annotate_fet_params  IS MISSING !!!!
*  h3 -  launcher  IS MISSING !!!!
Vd net4 net2 0
.save i(vd)
Vg net3 net7 0
.save i(vg)
?
*  M_BIAS -  nfet3_01v8_lvt  IS MISSING !!!!
L2 net6 net3 1 m=1
C1 net6 GND 1 m=1
E1 net4 net5 net6 net5 1
*  l5 -  gnd  IS MISSING !!!!
*  l6 -  lab_wire  IS MISSING !!!!
*  annot2 -  annotate_fet_params  IS MISSING !!!!
.ends
