** sch_path: /home/omare/Documents/UWASIC/Schemify/test/examples/xschem_sky130/sky130_tests/bandgap.sch
.subckt bandgap START CLK EN_N VBG VCC VSS

*  l1 -  title  IS MISSING !!!!
*  p1 -  ipin  IS MISSING !!!!
*  p2 -  opin  IS MISSING !!!!
*  Q1 -  pnp_05v5  IS MISSING !!!!
*  Q2 -  pnp_05v5  IS MISSING !!!!
*  l2 -  lab_pin  IS MISSING !!!!
*  Vc1 -  ammeter  IS MISSING !!!!
*  Vb1 -  ammeter  IS MISSING !!!!
*  Vb2 -  ammeter  IS MISSING !!!!
*  Vc2 -  ammeter  IS MISSING !!!!
*  l26 -  lab_pin  IS MISSING !!!!
*  l27 -  lab_pin  IS MISSING !!!!
*  l28 -  lab_pin  IS MISSING !!!!
*  x1 -  bandgap_opamp  IS MISSING !!!!
*  l30 -  lab_pin  IS MISSING !!!!
*  l31 -  lab_pin  IS MISSING !!!!
*  l32 -  lab_pin  IS MISSING !!!!
*  p3 -  ipin  IS MISSING !!!!
*  l3 -  lab_pin  IS MISSING !!!!
*  p4 -  ipin  IS MISSING !!!!
*  V1 -  ammeter  IS MISSING !!!!
*  V2 -  ammeter  IS MISSING !!!!
*  p5 -  lab_pin  IS MISSING !!!!
*  p6 -  lab_pin  IS MISSING !!!!
*  x2 -  zero_opamp  IS MISSING !!!!
*  x3 -  passgate  IS MISSING !!!!
*  x4 -  passgate  IS MISSING !!!!
*  l23 -  lab_pin  IS MISSING !!!!
*  l24 -  lab_pin  IS MISSING !!!!
*  l66 -  lab_pin  IS MISSING !!!!
*  l67 -  lab_pin  IS MISSING !!!!
*  l25 -  lab_pin  IS MISSING !!!!
*  l29 -  lab_pin  IS MISSING !!!!
*  l33 -  lab_pin  IS MISSING !!!!
*  x5 -  passgate  IS MISSING !!!!
*  x6 -  passgate  IS MISSING !!!!
*  l34 -  lab_pin  IS MISSING !!!!
*  l35 -  lab_pin  IS MISSING !!!!
*  l36 -  lab_pin  IS MISSING !!!!
*  l37 -  lab_pin  IS MISSING !!!!
*  l38 -  lab_pin  IS MISSING !!!!
*  l255 -  lab_pin  IS MISSING !!!!
*  l41 -  lab_pin  IS MISSING !!!!
*  l42 -  lab_pin  IS MISSING !!!!
*  l43 -  lab_pin  IS MISSING !!!!
*  l44 -  lab_pin  IS MISSING !!!!
*  l243 -  lab_pin  IS MISSING !!!!
*  l244 -  lab_pin  IS MISSING !!!!
*  l61 -  lab_pin  IS MISSING !!!!
*  l62 -  lab_pin  IS MISSING !!!!
*  x8 -  lvnand  IS MISSING !!!!
*  x9 -  lvnand  IS MISSING !!!!
*  x10 -  not  IS MISSING !!!!
*  x11 -  not  IS MISSING !!!!
*  x12 -  not  IS MISSING !!!!
*  x13 -  not  IS MISSING !!!!
*  x14 -  not  IS MISSING !!!!
*  x15 -  not  IS MISSING !!!!
*  x16 -  not  IS MISSING !!!!
*  x17 -  not  IS MISSING !!!!
*  x18 -  not  IS MISSING !!!!
*  x19 -  not  IS MISSING !!!!
*  x20 -  not  IS MISSING !!!!
*  c2 -  capa  IS MISSING !!!!
*  l45 -  lab_pin  IS MISSING !!!!
*  x7 -  passgate  IS MISSING !!!!
*  x21 -  not  IS MISSING !!!!
*  p15 -  lab_pin  IS MISSING !!!!
*  p16 -  lab_pin  IS MISSING !!!!
*  p8 -  lab_pin  IS MISSING !!!!
*  p9 -  lab_pin  IS MISSING !!!!
*  x22 -  not  IS MISSING !!!!
*  x23 -  not  IS MISSING !!!!
*  l22 -  lab_pin  IS MISSING !!!!
*  p10 -  ipin  IS MISSING !!!!
*  p7 -  ipin  IS MISSING !!!!
*  l21 -  lab_pin  IS MISSING !!!!
*  C2 -  cap_mim_m3_2  IS MISSING !!!!
*  l40 -  lab_pin  IS MISSING !!!!
*  C1 -  cap_mim_m3_2  IS MISSING !!!!
*  l39 -  lab_pin  IS MISSING !!!!
*  p14 -  spice_probe  IS MISSING !!!!
*  p17 -  spice_probe  IS MISSING !!!!
*  p18 -  spice_probe  IS MISSING !!!!
*  p19 -  spice_probe  IS MISSING !!!!
*  l6 -  lab_pin  IS MISSING !!!!
*  l4 -  lab_pin  IS MISSING !!!!
*  l7 -  lab_pin  IS MISSING !!!!
*  l12 -  lab_pin  IS MISSING !!!!
*  l15 -  lab_pin  IS MISSING !!!!
*  l19 -  lab_pin  IS MISSING !!!!
*  l20 -  lab_pin  IS MISSING !!!!
*  l46 -  lab_pin  IS MISSING !!!!
*  l47 -  lab_pin  IS MISSING !!!!
*  l48 -  lab_pin  IS MISSING !!!!
*  l49 -  lab_pin  IS MISSING !!!!
*  p15 -  spice_probe  IS MISSING !!!!
*  p1 -  spice_probe  IS MISSING !!!!
*  p2 -  spice_probe  IS MISSING !!!!
*  p3 -  spice_probe  IS MISSING !!!!
*  R12 -  res_xhigh_po_1p41  IS MISSING !!!!
*  R1 -  res_xhigh_po_1p41  IS MISSING !!!!
*  R2 -  res_xhigh_po_1p41  IS MISSING !!!!
*  R3 -  res_xhigh_po_1p41  IS MISSING !!!!
*  R4 -  res_xhigh_po_1p41  IS MISSING !!!!
*  R5 -  res_xhigh_po_1p41  IS MISSING !!!!
*  R6 -  res_xhigh_po_1p41  IS MISSING !!!!
*  R7 -  res_xhigh_po_1p41  IS MISSING !!!!
*  R8 -  res_xhigh_po_1p41  IS MISSING !!!!
*  R9 -  res_xhigh_po_1p41  IS MISSING !!!!
*  R10 -  res_xhigh_po_1p41  IS MISSING !!!!
*  C3 -  cap_mim_m3_2  IS MISSING !!!!
*  C4 -  cap_mim_m3_2  IS MISSING !!!!
*  l5 -  lab_pin  IS MISSING !!!!
*  l8 -  lab_pin  IS MISSING !!!!
.ends
