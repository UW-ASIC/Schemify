** sch_path: /home/omare/Documents/UWASIC/Schemify/test/examples/xschem_sky130/sky130_tests/test_res.sch
.subckt test_res

*  NGSPICE -  code_shown  IS MISSING !!!!
*  l1 -  title  IS MISSING !!!!
*  p22 -  lab_pin  IS MISSING !!!!
*  R1 -  res_iso_pw  IS MISSING !!!!
*  p1 -  lab_pin  IS MISSING !!!!
*  p2 -  lab_pin  IS MISSING !!!!
*  Vr1 -  ammeter  IS MISSING !!!!
*  Vr2 -  ammeter  IS MISSING !!!!
*  p3 -  lab_pin  IS MISSING !!!!
*  p4 -  lab_pin  IS MISSING !!!!
*  R2 -  res_generic_nd  IS MISSING !!!!
*  Vr3 -  ammeter  IS MISSING !!!!
*  p6 -  lab_pin  IS MISSING !!!!
*  p7 -  lab_pin  IS MISSING !!!!
*  R3 -  res_generic_pd  IS MISSING !!!!
*  Vr4 -  ammeter  IS MISSING !!!!
*  p9 -  lab_pin  IS MISSING !!!!
*  p10 -  lab_pin  IS MISSING !!!!
*  R4 -  res_generic_po  IS MISSING !!!!
*  Vr5 -  ammeter  IS MISSING !!!!
*  p12 -  lab_pin  IS MISSING !!!!
*  p13 -  lab_pin  IS MISSING !!!!
*  p14 -  lab_pin  IS MISSING !!!!
*  R5 -  res_high_po  IS MISSING !!!!
*  Vr6 -  ammeter  IS MISSING !!!!
*  p15 -  lab_pin  IS MISSING !!!!
*  p16 -  lab_pin  IS MISSING !!!!
*  p17 -  lab_pin  IS MISSING !!!!
*  R6 -  res_high_po_0p35  IS MISSING !!!!
*  Vr7 -  ammeter  IS MISSING !!!!
*  p18 -  lab_pin  IS MISSING !!!!
*  p19 -  lab_pin  IS MISSING !!!!
*  p20 -  lab_pin  IS MISSING !!!!
*  R7 -  res_high_po_0p69  IS MISSING !!!!
*  Vr8 -  ammeter  IS MISSING !!!!
*  p21 -  lab_pin  IS MISSING !!!!
*  p23 -  lab_pin  IS MISSING !!!!
*  p24 -  lab_pin  IS MISSING !!!!
*  R8 -  res_high_po_1p41  IS MISSING !!!!
*  Vr9 -  ammeter  IS MISSING !!!!
*  p25 -  lab_pin  IS MISSING !!!!
*  p26 -  lab_pin  IS MISSING !!!!
*  p27 -  lab_pin  IS MISSING !!!!
*  R9 -  res_xhigh_po  IS MISSING !!!!
*  Vr10 -  ammeter  IS MISSING !!!!
*  p28 -  lab_pin  IS MISSING !!!!
*  p29 -  lab_pin  IS MISSING !!!!
*  p30 -  lab_pin  IS MISSING !!!!
*  R10 -  res_xhigh_po_0p35  IS MISSING !!!!
*  Vr11 -  ammeter  IS MISSING !!!!
*  p31 -  lab_pin  IS MISSING !!!!
*  p32 -  lab_pin  IS MISSING !!!!
*  p33 -  lab_pin  IS MISSING !!!!
*  R11 -  res_xhigh_po_0p69  IS MISSING !!!!
*  Vr12 -  ammeter  IS MISSING !!!!
*  p34 -  lab_pin  IS MISSING !!!!
*  p35 -  lab_pin  IS MISSING !!!!
*  p36 -  lab_pin  IS MISSING !!!!
*  R12 -  res_xhigh_po_1p41  IS MISSING !!!!
*  p45 -  ipin  IS MISSING !!!!
*  p46 -  ipin  IS MISSING !!!!
*  p47 -  ipin  IS MISSING !!!!
*  Vr14 -  ammeter  IS MISSING !!!!
*  p11 -  lab_pin  IS MISSING !!!!
*  p37 -  lab_pin  IS MISSING !!!!
*  R14 -  res_generic_m1  IS MISSING !!!!
*  p5 -  lab_pin  IS MISSING !!!!
*  p8 -  lab_pin  IS MISSING !!!!
*  Vr13 -  ammeter  IS MISSING !!!!
*  p38 -  lab_pin  IS MISSING !!!!
*  p39 -  lab_pin  IS MISSING !!!!
*  p40 -  lab_pin  IS MISSING !!!!
*  R13 -  res_xhigh_po_2p85  IS MISSING !!!!
*  h5 -  launcher  IS MISSING !!!!
*  CORNER -  corner  IS MISSING !!!!
*  Vr15 -  ammeter  IS MISSING !!!!
*  p41 -  lab_pin  IS MISSING !!!!
*  p42 -  lab_pin  IS MISSING !!!!
*  p43 -  lab_pin  IS MISSING !!!!
*  R15 -  res_high_po_2p85  IS MISSING !!!!
*  Vr16 -  ammeter  IS MISSING !!!!
*  p44 -  lab_pin  IS MISSING !!!!
*  p48 -  lab_pin  IS MISSING !!!!
*  p49 -  lab_pin  IS MISSING !!!!
*  Vr17 -  ammeter  IS MISSING !!!!
*  p50 -  lab_pin  IS MISSING !!!!
*  p51 -  lab_pin  IS MISSING !!!!
*  p52 -  lab_pin  IS MISSING !!!!
*  R16 -  res_xhigh_po_5p73  IS MISSING !!!!
*  R17 -  res_high_po_5p73  IS MISSING !!!!
*  Vr18 -  ammeter  IS MISSING !!!!
*  p53 -  lab_pin  IS MISSING !!!!
*  p54 -  lab_pin  IS MISSING !!!!
*  R18 -  res_generic_m2  IS MISSING !!!!
*  Vr19 -  ammeter  IS MISSING !!!!
*  p55 -  lab_pin  IS MISSING !!!!
*  p56 -  lab_pin  IS MISSING !!!!
*  R19 -  res_generic_l1  IS MISSING !!!!
*  Vr20 -  ammeter  IS MISSING !!!!
*  p57 -  lab_pin  IS MISSING !!!!
*  p58 -  lab_pin  IS MISSING !!!!
*  Vr21 -  ammeter  IS MISSING !!!!
*  p59 -  lab_pin  IS MISSING !!!!
*  p60 -  lab_pin  IS MISSING !!!!
*  Vr22 -  ammeter  IS MISSING !!!!
*  p61 -  lab_pin  IS MISSING !!!!
*  p62 -  lab_pin  IS MISSING !!!!
*  R21 -  res_generic_m4  IS MISSING !!!!
*  R20 -  res_generic_m3  IS MISSING !!!!
*  R22 -  res_generic_m5  IS MISSING !!!!
*  Vr23 -  ammeter  IS MISSING !!!!
*  p63 -  lab_pin  IS MISSING !!!!
*  p64 -  lab_pin  IS MISSING !!!!
*  p65 -  lab_pin  IS MISSING !!!!
*  R23 -  res_high_po  IS MISSING !!!!
*  Vr24 -  ammeter  IS MISSING !!!!
*  p66 -  lab_pin  IS MISSING !!!!
*  p67 -  lab_pin  IS MISSING !!!!
*  p68 -  lab_pin  IS MISSING !!!!
*  R24 -  res_high_po_0p35  IS MISSING !!!!
*  Vr25 -  ammeter  IS MISSING !!!!
*  p69 -  lab_pin  IS MISSING !!!!
*  p70 -  lab_pin  IS MISSING !!!!
*  p71 -  lab_pin  IS MISSING !!!!
*  R25 -  res_high_po_0p69  IS MISSING !!!!
*  Vr26 -  ammeter  IS MISSING !!!!
*  p72 -  lab_pin  IS MISSING !!!!
*  p73 -  lab_pin  IS MISSING !!!!
*  p74 -  lab_pin  IS MISSING !!!!
*  R26 -  res_high_po_1p41  IS MISSING !!!!
*  Vr27 -  ammeter  IS MISSING !!!!
*  p75 -  lab_pin  IS MISSING !!!!
*  p76 -  lab_pin  IS MISSING !!!!
*  p77 -  lab_pin  IS MISSING !!!!
*  R27 -  res_high_po_2p85  IS MISSING !!!!
*  Vr28 -  ammeter  IS MISSING !!!!
*  p78 -  lab_pin  IS MISSING !!!!
*  p79 -  lab_pin  IS MISSING !!!!
*  p80 -  lab_pin  IS MISSING !!!!
*  R28 -  res_high_po_5p73  IS MISSING !!!!
.ends
