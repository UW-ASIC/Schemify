** sch_path: /home/omare/Documents/UWASIC/Schemify/test/examples/xschem_sky130/sky130_tests/ota1tb.sch
.subckt ota1tb VDD minus plus out gnd
*.PININFO minus:I plus:I VDD:I gnd:I out:O
*  M6 -  nfet3_01v8  IS MISSING !!!!
*  M8 -  nfet3_01v8  IS MISSING !!!!
*  M1 -  pfet3_01v8_lvt  IS MISSING !!!!
*  M3 -  nfet3_01v8  IS MISSING !!!!
*  M4 -  pfet3_01v8  IS MISSING !!!!
*  M2 -  pfet3_01v8_lvt  IS MISSING !!!!
*  R4 -  res_xhigh_po_1p41  IS MISSING !!!!
*  C3 -  cap_mim_m3_1  IS MISSING !!!!
*  M7 -  pfet3_01v8  IS MISSING !!!!
*  M5 -  pfet3_01v8  IS MISSING !!!!
*  R8 -  res_xhigh_po_1p41  IS MISSING !!!!
*  R5 -  res_xhigh_po_1p41  IS MISSING !!!!
*  R6 -  res_xhigh_po_1p41  IS MISSING !!!!
*  R9 -  res_xhigh_po_1p41  IS MISSING !!!!
.ends
