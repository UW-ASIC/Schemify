** sch_path: /home/omare/Documents/UWASIC/Schemify/test/examples/xschem_sky130/sky130_tests/test_format_override.sch
.subckt test_format_override

*  l1 -  title  IS MISSING !!!!
x1 VCC VSS VCC VSS AND2
*  p1 -  lab_pin  IS MISSING !!!!
*  p2 -  lab_pin  IS MISSING !!!!
*  p3 -  lab_pin  IS MISSING !!!!
*  x2 -  AND2  IS MISSING !!!!
*  p4 -  lab_pin  IS MISSING !!!!
*  p5 -  lab_pin  IS MISSING !!!!
*  p6 -  lab_pin  IS MISSING !!!!
*  p8 -  lab_pin  IS MISSING !!!!
*  p9 -  lab_pin  IS MISSING !!!!
*  p11 -  lab_pin  IS MISSING !!!!
*  p12 -  lab_pin  IS MISSING !!!!
*  l2 -  noconn  IS MISSING !!!!
*  l3 -  noconn  IS MISSING !!!!
*  l4 -  noconn  IS MISSING !!!!
*  l5 -  noconn  IS MISSING !!!!
.ends
