** sch_path: /nix/store/qriw4afhakn3sqg2al06kdyr745hx86w-xschem-3.4.7/share/doc/xschem/examples/lm337.sch
.subckt lm337 IN ADJ OUT
*.PININFO IN:I ADJ:I OUT:O
.ends
