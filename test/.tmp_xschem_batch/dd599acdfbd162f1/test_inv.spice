** sch_path: /home/omare/Documents/UWASIC/Schemify/test/examples/xschem_sky130/sky130_tests/test_inv.sch
.subckt test_inv

*  l1 -  title  IS MISSING !!!!
*  C1 -  parax_cap  IS MISSING !!!!
*  C2 -  parax_cap  IS MISSING !!!!
*  C3 -  parax_cap  IS MISSING !!!!
*  C4 -  parax_cap  IS MISSING !!!!
*  C5 -  parax_cap  IS MISSING !!!!
*  C6 -  parax_cap  IS MISSING !!!!
*  C7 -  parax_cap  IS MISSING !!!!
*  l9 -  lab_pin  IS MISSING !!!!
*  C8 -  parax_cap  IS MISSING !!!!
*  C9 -  parax_cap  IS MISSING !!!!
*  C10 -  parax_cap  IS MISSING !!!!
*  C11 -  parax_cap  IS MISSING !!!!
*  C12 -  parax_cap  IS MISSING !!!!
*  C13 -  parax_cap  IS MISSING !!!!
*  C14 -  parax_cap  IS MISSING !!!!
*  l17 -  lab_pin  IS MISSING !!!!
*  x4 -  not  IS MISSING !!!!
*  x1 -  not  IS MISSING !!!!
*  x2 -  not  IS MISSING !!!!
*  x3 -  not  IS MISSING !!!!
*  x5 -  not  IS MISSING !!!!
*  x6 -  not  IS MISSING !!!!
*  x7 -  not  IS MISSING !!!!
*  x8 -  lvtnot  IS MISSING !!!!
*  x9 -  lvtnot  IS MISSING !!!!
*  x10 -  lvtnot  IS MISSING !!!!
*  x11 -  lvtnot  IS MISSING !!!!
*  x12 -  lvtnot  IS MISSING !!!!
*  x13 -  lvtnot  IS MISSING !!!!
*  x14 -  lvtnot  IS MISSING !!!!
*  h3 -  launcher  IS MISSING !!!!
*  COMMANDS2 -  simulator_commands_shown  IS MISSING !!!!
*  COMMANDS1 -  simulator_commands_shown  IS MISSING !!!!
*  l19 -  bus_tap  IS MISSING !!!!
*  l2 -  bus_tap  IS MISSING !!!!
*  l3 -  bus_tap  IS MISSING !!!!
*  l4 -  bus_tap  IS MISSING !!!!
*  l5 -  bus_tap  IS MISSING !!!!
*  l6 -  bus_tap  IS MISSING !!!!
*  l7 -  bus_tap  IS MISSING !!!!
*  l8 -  bus_tap  IS MISSING !!!!
*  l10 -  bus_tap  IS MISSING !!!!
*  l11 -  bus_tap  IS MISSING !!!!
*  l12 -  bus_tap  IS MISSING !!!!
*  l13 -  bus_tap  IS MISSING !!!!
*  l14 -  bus_tap  IS MISSING !!!!
*  l15 -  bus_tap  IS MISSING !!!!
?
.ends
