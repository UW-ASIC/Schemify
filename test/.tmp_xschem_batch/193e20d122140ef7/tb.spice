** sch_path: /home/omare/Documents/UWASIC/Schemify/test/examples/xschem_sky130/mips_cpu/tb.sch
.subckt tb

*  l1 -  title  IS MISSING !!!!
*  xuut -  top  IS MISSING !!!!
*  p1 -  lab_pin  IS MISSING !!!!
*  p3 -  lab_pin  IS MISSING !!!!
*  x1 -    IS MISSING !!!!
*  s1 -  verilog_preprocessor  IS MISSING !!!!
*  h1 -  launcher  IS MISSING !!!!
*  l3 -  noconn  IS MISSING !!!!
*  l2 -  noconn  IS MISSING !!!!
.ends
