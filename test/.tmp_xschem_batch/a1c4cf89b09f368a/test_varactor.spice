** sch_path: /home/omare/Documents/UWASIC/Schemify/test/examples/xschem_sky130/sky130_tests/test_varactor.sch
.subckt test_varactor

*  NGSPICE -  code_shown  IS MISSING !!!!
*  l1 -  title  IS MISSING !!!!
*  p4 -  lab_pin  IS MISSING !!!!
*  I1 -  isource  IS MISSING !!!!
*  p1 -  lab_pin  IS MISSING !!!!
*  p2 -  lab_pin  IS MISSING !!!!
*  R1 -  res  IS MISSING !!!!
*  p5 -  lab_pin  IS MISSING !!!!
*  p6 -  lab_pin  IS MISSING !!!!
*  I2 -  isource  IS MISSING !!!!
*  p7 -  lab_pin  IS MISSING !!!!
*  p8 -  lab_pin  IS MISSING !!!!
*  R2 -  res  IS MISSING !!!!
*  p10 -  lab_pin  IS MISSING !!!!
*  V1 -  vsource  IS MISSING !!!!
*  p14 -  lab_pin  IS MISSING !!!!
*  p15 -  lab_pin  IS MISSING !!!!
*  C4 -  cap_var_lvt  IS MISSING !!!!
*  p20 -  lab_pin  IS MISSING !!!!
?
*  h1 -  launcher  IS MISSING !!!!
*  M2 -  pfet_01v8  IS MISSING !!!!
*  p4 -  lab_pin  IS MISSING !!!!
*  I3 -  isource  IS MISSING !!!!
*  p1 -  lab_pin  IS MISSING !!!!
*  p2 -  lab_pin  IS MISSING !!!!
*  R3 -  res  IS MISSING !!!!
*  p5 -  lab_pin  IS MISSING !!!!
*  C1 -  cap_var_lvt  IS MISSING !!!!
*  p20 -  lab_pin  IS MISSING !!!!
*  V3 -  vsource  IS MISSING !!!!
*  r4 -  ngspice_probe  IS MISSING !!!!
*  r4 -  ngspice_probe  IS MISSING !!!!
*  r4 -  ngspice_probe  IS MISSING !!!!
.ends
