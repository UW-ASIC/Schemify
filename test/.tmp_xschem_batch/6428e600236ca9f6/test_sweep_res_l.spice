** sch_path: /home/omare/Documents/UWASIC/Schemify/test/examples/xschem_sky130/sky130_tests/test_sweep_res_l.sch
.subckt test_sweep_res_l

*  V2 -  vsource  IS MISSING !!!!
*  l1 -  gnd  IS MISSING !!!!
*  p1 -  lab_wire  IS MISSING !!!!
*  CORNER -  corner  IS MISSING !!!!
*  l2 -  title  IS MISSING !!!!
*  COMMANDS -  simulator_commands_shown  IS MISSING !!!!
*  h5 -  launcher  IS MISSING !!!!
*  R1 -  res_high_po_0p69  IS MISSING !!!!
.ends
