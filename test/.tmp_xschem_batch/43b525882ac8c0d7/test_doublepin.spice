** sch_path: /nix/store/qriw4afhakn3sqg2al06kdyr745hx86w-xschem-3.4.7/share/doc/xschem/examples/test_doublepin.sch
.subckt test_doublepin RRSSTT CCKK BB AA[3] AA[2] AA[1] AA[0] ZZ[22] ZZ[21] ZZ[20] ZZ[19] ZZ[18] ZZ[17] ZZ[16] ZZ[15] ZZ[14]
+ ZZ[13] ZZ[12] ZZ[11] ZZ[10] ZZ[9] ZZ[8] ZZ[7] ZZ[6] ZZ[5] ZZ[4] ZZ[3] ZZ[2] ZZ[1]
*.PININFO RRSSTT:B CCKK:B BB:B AA[3:0]:B ZZ[22:1]:O
x9 AA[3] AA[2] AA[1] AA[0] BB CCKK RRSSTT ZZ[9] doublepin
x8 AA[3] AA[2] AA[1] AA[0] BB CCKK RRSSTT ZZ[8] doublepin
x2 AA[3] AA[2] AA[1] AA[0] BB CCKK RRSSTT ZZ[6] doublepin
x3 AA[3] AA[2] AA[1] AA[0] BB CCKK RRSSTT ZZ[3] doublepin
x4 AA[3] AA[2] AA[1] AA[0] BB CCKK RRSSTT ZZ[4] doublepin
x5 AA[3] AA[2] AA[1] AA[0] BB CCKK RRSSTT ZZ[1] doublepin
x6 AA[3] AA[2] AA[1] AA[0] BB CCKK RRSSTT ZZ[2] doublepin
x1 AA[3] AA[2] AA[1] AA[0] BB CCKK RRSSTT ZZ[5] doublepin
x7 AA[3] AA[2] AA[1] AA[0] BB CCKK RRSSTT ZZ[7] doublepin
x10 net3[3] net3[2] net3[1] net3[0] net4 net2 net1 ZZ[10] doublepin
x11 net3[3] net3[2] net3[1] net3[0] net4 net2 net1 ZZ[11] doublepin
x12 net3[3] net3[2] net3[1] net3[0] net4 net2 net1 ZZ[12] doublepin
x13 AA[3] AA[2] AA[1] AA[0] BB CCKK RRSSTT ZZ[13] doublepin
x14 AA[3] AA[2] AA[1] AA[0] BB CCKK RRSSTT ZZ[14] doublepin
x17[1] net7[7] net7[6] net7[5] net7[4] net8[1] net6 net5 ZZ[17] doublepin
x17[0] net7[3] net7[2] net7[1] net7[0] net8[0] net6 net5 ZZ[17] doublepin
x16[1] net7[7] net7[6] net7[5] net7[4] net8[1] net6 net5 ZZ[16] doublepin
x16[0] net7[3] net7[2] net7[1] net7[0] net8[0] net6 net5 ZZ[16] doublepin
x22[1] net7[7] net7[6] net7[5] net7[4] net8[1] net6 net5 ZZ[15] doublepin
x22[0] net7[3] net7[2] net7[1] net7[0] net8[0] net6 net5 ZZ[15] doublepin
x18 net6 net9 inv_ngspice RUP=2000 RDOWN=1000
x19 net4 net10 inv_ngspice RUP=2000 RDOWN=1000
x20 net3[3] net3[2] net3[1] net3[0] net4 net2 net1 ZZ[18] doublepin
x21 net3[3] net3[2] net3[1] net3[0] net4 net2 net1 ZZ[19] doublepin
x15 net11 net5 inv_ngspice RUP=2000 RDOWN=1000
x23 AA[3] AA[2] AA[1] AA[0] BB CCKK RRSSTT ZZ[20] doublepin
x24 AA[3] AA[2] AA[1] AA[0] BB CCKK RRSSTT ZZ[21] doublepin
x25 BB RRSSTT xcross
x26 BB RRSSTT xcross
x27 BB RRSSTT xcross
x28 RRSSTT BB xcross
x29 RRSSTT BB xcross
x30 net12[3] net12[2] net12[1] net12[0] RRSSTT net13 BB ZZ[22] doublepin
x31 RRSSTT BB xcross
**** begin user architecture code

.param VCC=2
vaa3 aa[3] 0 dc 0
vaa2 aa[2] 0 dc 0
vaa1 aa[1] 0 dc 0
vaa0 aa[0] 0 dc 0
vbb bb 0 dc 0
vcckk cckk 0 dc 0
vrrsstt rrsstt 0 dc 0
.op

**** end user architecture code
.ends

* expanding   symbol:  doublepin.sym # of pins=9
** sym_path: /nix/store/qriw4afhakn3sqg2al06kdyr745hx86w-xschem-3.4.7/share/doc/xschem/examples/doublepin.sym
** sch_path: /nix/store/qriw4afhakn3sqg2al06kdyr745hx86w-xschem-3.4.7/share/doc/xschem/examples/doublepin.sch
.subckt doublepin A[3] A[2] A[1] A[0] B CK RST Z
*.PININFO A[3:0]:I B:I Z:O RST:I CK:I
x2[3] A[3] Z CK RST NC4 latch
x2[2] A[2] NC1 CK RST NC5 latch
x2[1] A[1] NC2 CK RST NC6 latch
x2[0] A[0] NC3 CK RST NC7 latch
* noconn B
.ends

* expanding   symbol:  inv_ngspice.sym # of pins=2
** sym_path: /nix/store/qriw4afhakn3sqg2al06kdyr745hx86w-xschem-3.4.7/share/doc/xschem/ngspice/inv_ngspice.sym
** sch_path: /nix/store/qriw4afhakn3sqg2al06kdyr745hx86w-xschem-3.4.7/share/doc/xschem/ngspice/inv_ngspice.sch
.subckt inv_ngspice Y A  RUP=2000 RDOWN=1000
*.PININFO A:I Y:O
B1 X1 0 V = 'VCC/2*(1-tanh((V(A1)-VCC/2)*100))' m=1
C1 A1 0 8f m=1
C2 Y1 0 8f m=1
V1 Y Y1 0
.save i(v1)
V2 A1 A 0
.save i(v2)
B2 X1 Y1 I = 'v(X1,Y1) > 0 ? v(X1,Y1) / RUP : v(X1,Y1) / RDOWN' m=1
.ends

* expanding   symbol:  xcross.sym # of pins=6
** sym_path: /nix/store/qriw4afhakn3sqg2al06kdyr745hx86w-xschem-3.4.7/share/doc/xschem/examples/xcross.sym
** sch_path: /nix/store/qriw4afhakn3sqg2al06kdyr745hx86w-xschem-3.4.7/share/doc/xschem/examples/xcross.sch
.subckt xcross A B
*.PININFO A:B B:B
R1 A B 1k m=1
.ends

* expanding   symbol:  latch.sym # of pins=5
** sym_path: /nix/store/qriw4afhakn3sqg2al06kdyr745hx86w-xschem-3.4.7/share/doc/xschem/logic/latch.sym
** sch_path: /nix/store/qriw4afhakn3sqg2al06kdyr745hx86w-xschem-3.4.7/share/doc/xschem/logic/latch.sch
.subckt latch D Q G RST QN  delay=200 ps del=200
*.PININFO Q:O G:I RST:I QN:O D:I
* noconn Q
* noconn QN
* noconn RST
* noconn D
* noconn G
.ends
