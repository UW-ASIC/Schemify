** sch_path: /nix/store/qriw4afhakn3sqg2al06kdyr745hx86w-xschem-3.4.7/share/doc/xschem/ngspice/tb_diff_amp.sch
.subckt tb_diff_amp

V1 A 0 1.51
V2 B 0 1.5
X1 Z A B diff_amp_cell gain=100 amplitude=5 offset=2.5
**** begin user architecture code

.options savecurrents
.control
  save all
  op
  remzerovec
  write tb_diff_amp.raw
  dc V1 1.1 1.9 0.001
  set appendwrite
  remzerovec
  write tb_diff_amp.raw
  * quit 0
.endc

**** end user architecture code
.ends
**** begin user architecture code

.control
* following line specifies the location for the .osdi file so ngspice can use it.
pre_osdi /home/omare/.xschem/xschem_library/diff_amp.osdi
.endc

.model diff_amp_model diff_amp $ gain=40 amplitude=3 offset=1.5

.subckt diff_amp_cell OUT IN1 IN2 gain=40 amplitude=3 offset=1.5
N1 out in1 in2 diff_amp_model gain=gain amplitude=amplitude offset=offset
.ends diff_amp_cell

**** end user architecture code
