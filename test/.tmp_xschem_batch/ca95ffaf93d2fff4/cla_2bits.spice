** sch_path: /home/omare/Documents/UWASIC/Schemify/test/examples/xschem_sky130/sky130_tests/cla_2bits.sch
.subckt cla_2bits SG SP C1 P[1] P[0] C2 G[1] G[0] C0

*  p1 -  ipin  IS MISSING !!!!
*  p2 -  ipin  IS MISSING !!!!
*  p3 -  ipin  IS MISSING !!!!
*  l2 -  title  IS MISSING !!!!
*  p7 -  opin  IS MISSING !!!!
*  p9 -  opin  IS MISSING !!!!
*  p58 -  opin  IS MISSING !!!!
*  p59 -  opin  IS MISSING !!!!
*  p56 -  lab_pin  IS MISSING !!!!
*  p57 -  lab_pin  IS MISSING !!!!
*  p60 -  lab_pin  IS MISSING !!!!
*  p61 -  lab_pin  IS MISSING !!!!
*  p62 -  lab_pin  IS MISSING !!!!
*  p63 -  lab_pin  IS MISSING !!!!
*  x17 -  inv_1  IS MISSING !!!!
*  x18 -  a21oi_1  IS MISSING !!!!
*  C17 -  parax_cap  IS MISSING !!!!
*  C18 -  parax_cap  IS MISSING !!!!
*  p64 -  lab_pin  IS MISSING !!!!
*  p65 -  lab_pin  IS MISSING !!!!
*  p67 -  lab_pin  IS MISSING !!!!
*  x19 -  nand2_1  IS MISSING !!!!
*  C19 -  parax_cap  IS MISSING !!!!
*  p66 -  lab_pin  IS MISSING !!!!
*  p68 -  lab_pin  IS MISSING !!!!
*  p69 -  lab_pin  IS MISSING !!!!
*  p70 -  lab_pin  IS MISSING !!!!
*  x20 -  nand3_1  IS MISSING !!!!
*  C20 -  parax_cap  IS MISSING !!!!
*  p71 -  lab_pin  IS MISSING !!!!
*  p72 -  lab_pin  IS MISSING !!!!
*  p73 -  lab_pin  IS MISSING !!!!
*  x21 -  nand2_1  IS MISSING !!!!
*  p74 -  lab_pin  IS MISSING !!!!
*  p75 -  lab_pin  IS MISSING !!!!
*  p76 -  lab_pin  IS MISSING !!!!
*  x22 -  and2_1  IS MISSING !!!!
*  p77 -  lab_pin  IS MISSING !!!!
*  p78 -  lab_pin  IS MISSING !!!!
*  x23 -  inv_1  IS MISSING !!!!
*  p79 -  lab_pin  IS MISSING !!!!
*  p80 -  lab_pin  IS MISSING !!!!
*  p81 -  lab_pin  IS MISSING !!!!
*  p82 -  lab_pin  IS MISSING !!!!
*  x24 -  nand3_1  IS MISSING !!!!
.ends
