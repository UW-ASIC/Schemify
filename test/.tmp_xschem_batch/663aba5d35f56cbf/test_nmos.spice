** sch_path: /home/omare/Documents/UWASIC/Schemify/test/examples/xschem_sky130/sky130_tests/test_nmos.sch
.subckt test_nmos

*  l1 -  title  IS MISSING !!!!
*  p17 -  lab_pin  IS MISSING !!!!
*  p3 -  lab_pin  IS MISSING !!!!
*  p4 -  lab_pin  IS MISSING !!!!
*  Vd1 -  ammeter  IS MISSING !!!!
*  p12 -  lab_pin  IS MISSING !!!!
*  p13 -  lab_pin  IS MISSING !!!!
*  Vd3 -  ammeter  IS MISSING !!!!
*  p16 -  lab_pin  IS MISSING !!!!
*  p21 -  lab_pin  IS MISSING !!!!
*  Vd2 -  ammeter  IS MISSING !!!!
*  p7 -  lab_pin  IS MISSING !!!!
*  p8 -  lab_pin  IS MISSING !!!!
*  Vd4 -  ammeter  IS MISSING !!!!
*  p9 -  lab_pin  IS MISSING !!!!
*  p14 -  lab_pin  IS MISSING !!!!
*  E1 -  vcvs  IS MISSING !!!!
*  p18 -  lab_pin  IS MISSING !!!!
*  p19 -  lab_pin  IS MISSING !!!!
*  p20 -  lab_pin  IS MISSING !!!!
*  p23 -  lab_pin  IS MISSING !!!!
*  E2 -  vcvs  IS MISSING !!!!
*  p24 -  lab_pin  IS MISSING !!!!
*  p25 -  lab_pin  IS MISSING !!!!
*  p26 -  lab_pin  IS MISSING !!!!
*  p27 -  lab_pin  IS MISSING !!!!
*  E3 -  vcvs  IS MISSING !!!!
*  p28 -  lab_pin  IS MISSING !!!!
*  p29 -  lab_pin  IS MISSING !!!!
*  p30 -  lab_pin  IS MISSING !!!!
*  p31 -  lab_pin  IS MISSING !!!!
*  E4 -  vcvs  IS MISSING !!!!
*  p32 -  lab_pin  IS MISSING !!!!
*  p33 -  lab_pin  IS MISSING !!!!
*  p34 -  lab_pin  IS MISSING !!!!
*  p35 -  lab_pin  IS MISSING !!!!
*  p2 -  lab_pin  IS MISSING !!!!
*  p6 -  lab_pin  IS MISSING !!!!
*  p11 -  lab_pin  IS MISSING !!!!
*  p15 -  lab_pin  IS MISSING !!!!
*  p1 -  lab_pin  IS MISSING !!!!
*  p5 -  lab_pin  IS MISSING !!!!
*  Vd5 -  ammeter  IS MISSING !!!!
*  p10 -  lab_pin  IS MISSING !!!!
*  p22 -  lab_pin  IS MISSING !!!!
*  E5 -  vcvs  IS MISSING !!!!
*  p36 -  lab_pin  IS MISSING !!!!
*  p37 -  lab_pin  IS MISSING !!!!
*  p38 -  lab_pin  IS MISSING !!!!
*  p39 -  lab_pin  IS MISSING !!!!
*  p1 -  lab_pin  IS MISSING !!!!
*  p5 -  lab_pin  IS MISSING !!!!
*  p10 -  lab_pin  IS MISSING !!!!
*  p22 -  lab_pin  IS MISSING !!!!
*  E6 -  vcvs  IS MISSING !!!!
*  p36 -  lab_pin  IS MISSING !!!!
*  p37 -  lab_pin  IS MISSING !!!!
*  p38 -  lab_pin  IS MISSING !!!!
*  p39 -  lab_pin  IS MISSING !!!!
*  Vd6 -  ammeter  IS MISSING !!!!
*  p40 -  lab_pin  IS MISSING !!!!
*  p41 -  lab_pin  IS MISSING !!!!
*  p42 -  lab_pin  IS MISSING !!!!
*  Vd7 -  ammeter  IS MISSING !!!!
*  p43 -  lab_pin  IS MISSING !!!!
*  E7 -  vcvs  IS MISSING !!!!
*  p44 -  lab_pin  IS MISSING !!!!
*  p45 -  lab_pin  IS MISSING !!!!
*  p46 -  lab_pin  IS MISSING !!!!
*  p47 -  lab_pin  IS MISSING !!!!
*  p48 -  ipin  IS MISSING !!!!
*  p49 -  ipin  IS MISSING !!!!
*  p50 -  ipin  IS MISSING !!!!
*  NGSPICE -  code_shown  IS MISSING !!!!
*  M1 -  nfet_01v8_lvt  IS MISSING !!!!
*  M2 -  nfet_01v8  IS MISSING !!!!
*  M3 -  nfet_03v3_nvt  IS MISSING !!!!
*  M4 -  nfet_05v0_nvt  IS MISSING !!!!
*  M5 -  nfet_g5v0d10v5  IS MISSING !!!!
*  M6 -  nfet_g5v0d16v0  IS MISSING !!!!
*  h2 -  launcher  IS MISSING !!!!
*  h3 -  launcher  IS MISSING !!!!
*  p51 -  lab_pin  IS MISSING !!!!
*  p52 -  lab_pin  IS MISSING !!!!
*  p53 -  lab_pin  IS MISSING !!!!
*  Vd8 -  ammeter  IS MISSING !!!!
*  M7 -  nfet_20v0  IS MISSING !!!!
*  M8 -  nfet_20v0_zvt  IS MISSING !!!!
*  h4 -  launcher  IS MISSING !!!!
*  p54 -  lab_pin  IS MISSING !!!!
*  p55 -  lab_pin  IS MISSING !!!!
*  Vd9 -  ammeter  IS MISSING !!!!
*  p56 -  lab_pin  IS MISSING !!!!
*  M9 -  nfet_01v8_lvt_nf  IS MISSING !!!!
*  CORNER -  corner  IS MISSING !!!!
*  r1 -  ngspice_probe  IS MISSING !!!!
*  r1 -  ngspice_probe  IS MISSING !!!!
*  r1 -  ngspice_probe  IS MISSING !!!!
*  h1 -  launcher  IS MISSING !!!!
*  p57 -  lab_pin  IS MISSING !!!!
*  Vd10 -  ammeter  IS MISSING !!!!
*  p59 -  lab_pin  IS MISSING !!!!
*  Vd11 -  ammeter  IS MISSING !!!!
*  p61 -  lab_pin  IS MISSING !!!!
*  Vd12 -  ammeter  IS MISSING !!!!
*  p63 -  lab_pin  IS MISSING !!!!
*  Vd13 -  ammeter  IS MISSING !!!!
*  p65 -  lab_pin  IS MISSING !!!!
*  p66 -  lab_pin  IS MISSING !!!!
*  p67 -  lab_pin  IS MISSING !!!!
*  p68 -  lab_pin  IS MISSING !!!!
*  p69 -  lab_pin  IS MISSING !!!!
*  Vd14 -  ammeter  IS MISSING !!!!
*  p71 -  lab_pin  IS MISSING !!!!
*  p72 -  lab_pin  IS MISSING !!!!
*  p74 -  lab_pin  IS MISSING !!!!
*  Vd15 -  ammeter  IS MISSING !!!!
*  p75 -  lab_pin  IS MISSING !!!!
*  p77 -  lab_pin  IS MISSING !!!!
*  Vd16 -  ammeter  IS MISSING !!!!
*  M10 -  nfet3_01v8_lvt  IS MISSING !!!!
*  M11 -  nfet3_01v8  IS MISSING !!!!
*  M12 -  nfet3_03v3_nvt  IS MISSING !!!!
*  M13 -  nfet3_05v0_nvt  IS MISSING !!!!
*  M14 -  nfet3_g5v0d10v5  IS MISSING !!!!
*  M15 -  nfet3_g5v0d16v0  IS MISSING !!!!
*  M16 -  nfet3_20v0  IS MISSING !!!!
*  r2 -  ngspice_probe  IS MISSING !!!!
*  M32 -  nfet_g5v0d10v5_nvt_esd  IS MISSING !!!!
*  p58 -  lab_pin  IS MISSING !!!!
*  p60 -  lab_pin  IS MISSING !!!!
*  p64 -  lab_pin  IS MISSING !!!!
*  Vd17 -  ammeter  IS MISSING !!!!
.ends
