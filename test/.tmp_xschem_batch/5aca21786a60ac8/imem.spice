** sch_path: /home/omare/Documents/UWASIC/Schemify/test/examples/xschem_sky130/mips_cpu/imem.sch
.subckt imem data[31] data[30] data[29] data[28] data[27] data[26] data[25] data[24] data[23] data[22] data[21] data[20] data[19]
+ data[18] data[17] data[16] data[15] data[14] data[13] data[12] data[11] data[10] data[9] data[8] data[7] data[6] data[5] data[4] data[3]
+ data[2] data[1] data[0] addr[5] addr[4] addr[3] addr[2] addr[1] addr[0]

*  l1 -  title  IS MISSING !!!!
*  p11 -  ipin  IS MISSING !!!!
*  p13 -  opin  IS MISSING !!!!
*  x1 -    IS MISSING !!!!
*  l5 -  noconn  IS MISSING !!!!
*  l6 -  noconn  IS MISSING !!!!
.ends
