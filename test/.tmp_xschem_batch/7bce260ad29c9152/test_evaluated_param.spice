** sch_path: /home/omare/Documents/UWASIC/Schemify/test/examples/xschem_core_examples/test_evaluated_param.sch
.subckt test_evaluated_param A Z
*.PININFO Z:B A:B
R1 Z A 2500 * @DEL m=1
C1 Z GND 100f * @DEL m=1
**** begin user architecture code

.param DEL=@DEL
** do something with DEL

**** end user architecture code
.ends
.GLOBAL GND
