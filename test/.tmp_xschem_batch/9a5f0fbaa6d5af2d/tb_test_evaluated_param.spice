** sch_path: /home/omare/Documents/UWASIC/Schemify/test/examples/xschem_core_examples/tb_test_evaluated_param.sch
.subckt tb_test_evaluated_param

x1 A Z2 test_evaluated_param2
V1 A GND pwl 0 0 10n 0 11n 3
x2 A Z1 test_evaluated_param1
**** begin user architecture code

.options savecurrents
** following .param is set with a TCL command
.param VCC=3
.control
  save all
  tran 10p 50n
  write tb_test_evaluated_param.raw
.endc

**** end user architecture code
.ends

* expanding   symbol:  test_evaluated_param2.sym # of pins=2
** sym_path: /home/omare/Documents/UWASIC/Schemify/test/examples/xschem_core_examples/test_evaluated_param.sym
** sch_path: /home/omare/Documents/UWASIC/Schemify/test/examples/xschem_core_examples/test_evaluated_param.sch
.subckt test_evaluated_param2 A Z
*.PININFO Z:B A:B
R1 Z A 12500 m=1
C1 Z GND 5e-13 m=1
**** begin user architecture code

.param DEL=5
** do something with DEL

**** end user architecture code
.ends

* expanding   symbol:  test_evaluated_param1.sym # of pins=2
** sym_path: /home/omare/Documents/UWASIC/Schemify/test/examples/xschem_core_examples/test_evaluated_param.sym
** sch_path: /home/omare/Documents/UWASIC/Schemify/test/examples/xschem_core_examples/test_evaluated_param.sch
.subckt test_evaluated_param1 A Z
*.PININFO Z:B A:B
R1 Z A 5000 m=1
C1 Z GND 2e-13 m=1
**** begin user architecture code

.param DEL=2
** do something with DEL

**** end user architecture code
.ends

.GLOBAL GND
