** sch_path: /home/omare/Documents/UWASIC/Schemify/test/examples/xschem_sky130/sky130_tests/adder_64bit.sch
.subckt adder_64bit A[63] A[62] A[61] A[60] A[59] A[58] A[57] A[56] A[55] A[54] A[53] A[52] A[51] A[50] A[49] A[48] A[47] A[46]
+ A[45] A[44] A[43] A[42] A[41] A[40] A[39] A[38] A[37] A[36] A[35] A[34] A[33] A[32] A[31] A[30] A[29] A[28] A[27] A[26] A[25] A[24]
+ A[23] A[22] A[21] A[20] A[19] A[18] A[17] A[16] A[15] A[14] A[13] A[12] A[11] A[10] A[9] A[8] A[7] A[6] A[5] A[4] A[3] A[2] A[1] A[0]
+ S[63] S[62] S[61] S[60] S[59] S[58] S[57] S[56] S[55] S[54] S[53] S[52] S[51] S[50] S[49] S[48] S[47] S[46] S[45] S[44] S[43] S[42]
+ S[41] S[40] S[39] S[38] S[37] S[36] S[35] S[34] S[33] S[32] S[31] S[30] S[29] S[28] S[27] S[26] S[25] S[24] S[23] S[22] S[21] S[20]
+ S[19] S[18] S[17] S[16] S[15] S[14] S[13] S[12] S[11] S[10] S[9] S[8] S[7] S[6] S[5] S[4] S[3] S[2] S[1] S[0] B[63] B[62] B[61] B[60]
+ B[59] B[58] B[57] B[56] B[55] B[54] B[53] B[52] B[51] B[50] B[49] B[48] B[47] B[46] B[45] B[44] B[43] B[42] B[41] B[40] B[39] B[38]
+ B[37] B[36] B[35] B[34] B[33] B[32] B[31] B[30] B[29] B[28] B[27] B[26] B[25] B[24] B[23] B[22] B[21] B[20] B[19] B[18] B[17] B[16]
+ B[15] B[14] B[13] B[12] B[11] B[10] B[9] B[8] B[7] B[6] B[5] B[4] B[3] B[2] B[1] B[0] COUT SG CIN SP

*  p1 -  ipin  IS MISSING !!!!
*  p2 -  ipin  IS MISSING !!!!
*  p3 -  ipin  IS MISSING !!!!
*  p4 -  opin  IS MISSING !!!!
*  l2 -  title  IS MISSING !!!!
*  xadd16[3],xadd16[2],xadd16[1],xadd16[0] -  adder_16bit  IS MISSING !!!!
*  p6 -  lab_pin  IS MISSING !!!!
*  p9 -  lab_pin  IS MISSING !!!!
*  p10 -  lab_pin  IS MISSING !!!!
*  p11 -  lab_pin  IS MISSING !!!!
*  p12 -  lab_pin  IS MISSING !!!!
*  p13 -  lab_pin  IS MISSING !!!!
*  xcla -  cla_4bits  IS MISSING !!!!
*  p14 -  lab_pin  IS MISSING !!!!
*  p15 -  lab_pin  IS MISSING !!!!
*  p16 -  lab_pin  IS MISSING !!!!
*  p17 -  lab_pin  IS MISSING !!!!
*  p18 -  lab_pin  IS MISSING !!!!
*  p19 -  lab_pin  IS MISSING !!!!
*  p20 -  lab_pin  IS MISSING !!!!
*  p21 -  lab_pin  IS MISSING !!!!
*  p22 -  lab_pin  IS MISSING !!!!
*  p7 -  opin  IS MISSING !!!!
*  p8 -  opin  IS MISSING !!!!
*  p5 -  opin  IS MISSING !!!!
*  l1 -  noconn  IS MISSING !!!!
.ends
