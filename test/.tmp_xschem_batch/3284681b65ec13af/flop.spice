** sch_path: /nix/store/qriw4afhakn3sqg2al06kdyr745hx86w-xschem-3.4.7/share/doc/xschem/examples/flop.sch
.subckt flop D Q CK VSS
*.PININFO D:I Q:O VSS:I CK:I
B5 net1 VSS V=pwl(v( CK , VSS ), 'VTH-0.1' VHI 'VTH+0.1' 0 )
x5 D net2 net1 VSS dlatch VTH=VTH VHI=VHI
x1 net2 Q CK VSS dlatch VTH=VTH VHI=VHI
.ends

* expanding   symbol:  dlatch.sym # of pins=4
** sym_path: /nix/store/qriw4afhakn3sqg2al06kdyr745hx86w-xschem-3.4.7/share/doc/xschem/examples/dlatch.sym
** sch_path: /nix/store/qriw4afhakn3sqg2al06kdyr745hx86w-xschem-3.4.7/share/doc/xschem/examples/dlatch.sch
.subckt dlatch D Q G VSS  VTH=1.5 VHI=3.0
*.PININFO D:I Q:O VSS:I G:I
G5 net2 net1 vcr pwl(1) G VSS 'VTH-0.1' 10G 'VTH+0.1' 10
c1 net2 VSS 1p m=1
E5 net1 VSS pwl(1) D VSS 'VTH-0.1' 0 'VTH+0.1' VHI
E1 Q VSS pwl(1) net2 VSS 'VTH-0.1' 0 'VTH+0.1' VHI
.ends
