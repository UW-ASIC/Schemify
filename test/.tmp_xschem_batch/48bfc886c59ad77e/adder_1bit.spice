** sch_path: /home/omare/Documents/UWASIC/Schemify/test/examples/xschem_sky130/sky130_tests/adder_1bit.sch
.subckt adder_1bit S A B G CIN P

*  p1 -  ipin  IS MISSING !!!!
*  p2 -  ipin  IS MISSING !!!!
*  p3 -  ipin  IS MISSING !!!!
*  p4 -  opin  IS MISSING !!!!
*  l2 -  title  IS MISSING !!!!
*  p7 -  opin  IS MISSING !!!!
*  p8 -  opin  IS MISSING !!!!
*  l4 -  lab_pin  IS MISSING !!!!
*  l5 -  lab_pin  IS MISSING !!!!
*  l11 -  lab_pin  IS MISSING !!!!
*  l12 -  lab_pin  IS MISSING !!!!
*  l13 -  lab_pin  IS MISSING !!!!
*  l14 -  lab_pin  IS MISSING !!!!
*  p6 -  lab_pin  IS MISSING !!!!
*  l15 -  lab_pin  IS MISSING !!!!
*  l1 -  lab_pin  IS MISSING !!!!
*  x4 -  and2_1  IS MISSING !!!!
*  x2 -  xor2_1  IS MISSING !!!!
*  x3 -  xor2_1  IS MISSING !!!!
*  C17 -  parax_cap  IS MISSING !!!!
*  C4 -  parax_cap  IS MISSING !!!!
*  C5 -  parax_cap  IS MISSING !!!!
.ends
