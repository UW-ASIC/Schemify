** sch_path: /home/omare/Documents/UWASIC/Schemify/test/examples/xschem_sky130/sky130_tests/test_carry_lookahead.sch
.subckt test_carry_lookahead

*  l2 -  title  IS MISSING !!!!
*  p11 -  ipin  IS MISSING !!!!
*  p12 -  ipin  IS MISSING !!!!
*  p13 -  ipin  IS MISSING !!!!
*  p21 -  lab_pin  IS MISSING !!!!
*  p22 -  lab_pin  IS MISSING !!!!
*  p23 -  lab_pin  IS MISSING !!!!
*
*+  xaddcarry256[255],xaddcarry256[254],xaddcarry256[253],xaddcarry256[252],xaddcarry256[251],xaddcarry256[250],xaddcarry256[249],xaddcarry256[248],xaddcarry256[247],xaddcarry256[246],xaddcarry256[245],xaddcarry256[244],xaddcarry256[243],xaddcarry256[242],xaddcarry256[241],xaddcarry256[240],xaddcarry256[239],xaddcarry256[238],xaddcarry256[237],xaddcarry256[236],xaddcarry256[235],xaddcarry256[234],xaddcarry256[233],xaddcarry256[232],xaddcarry256[231],xaddcarry256[230],xaddcarry256[229],xaddcarry256[228],xaddcarry256[227],xaddcarry256[226],xaddcarry256[225],xaddcarry256[224],xaddcarry256[223],xaddcarry256[222],xaddcarry256[221],xaddcarry256[220],xaddcarry256[219],xaddcarry256[218],xaddcarry256[217],xaddcarry256[216],xaddcarry256[215],xaddcarry256[214],xaddcarry256[213],xaddcarry256[212],xaddcarry256[211],xaddcarry256[210],xaddcarry256[209],xaddcarry256[208],xaddcarry256[207],xaddcarry256[206],xaddcarry256[205],xaddcarry256[204],xaddcarry256[203],xaddcarry256[202],xaddcarry256[201],xaddcarry256[200],xaddcarry256[199],xaddcarry256[198],xaddcarry256[197],xaddcarry256[196],xaddcarry256[195],xaddcarry256[194],xaddcarry256[193],xaddcarry256[192],xaddcarry256[191],xaddcarry256[190],xaddcarry256[189],xaddcarry256[188],xaddcarry256[187],xaddcarry256[186],xaddcarry256[185],xaddcarry256[184],xaddcarry256[183],xaddcarry256[182],xaddcarry256[181],xaddcarry256[180],xaddcarry256[179],xaddcarry256[178],xaddcarry256[177],xaddcarry256[176],xaddcarry256[175],xaddcarry256[174],xaddcarry256[173],xaddcarry256[172],xaddcarry256[171],xaddcarry256[170],xaddcarry256[169],xaddcarry256[168],xaddcarry256[167],xaddcarry256[166],xaddcarry256[165],xaddcarry256[164],xaddcarry256[163],xaddcarry256[162],xaddcarry256[161],xaddcarry256[160],xaddcarry256[159],xaddcarry256[158],xaddcarry256[157],xaddcarry256[156],xaddcarry256[155],xaddcarry256[154],xaddcarry256[153],xaddcarry256[152],xaddcarry256[151],xaddcarry256[150],xaddcarry256[149],xaddcarry256[148],xaddcarry256[147],xaddcarry256[146],xaddcarry256[145],xaddcarry256[144],xaddcarry256[143],xaddcarry256[142],xaddcarry256[141],xaddcarry256[140],xaddcarry256[139],xaddcarry256[138],xaddcarry256[137],xaddcarry256[136],xaddcarry256[135],xaddcarry256[134],xaddcarry256[133],xaddcarry256[132],xaddcarry256[131],xaddcarry256[130],xaddcarry256[129],xaddcarry256[128],xaddcarry256[127],xaddcarry256[126],xaddcarry256[125],xaddcarry256[124],xaddcarry256[123],xaddcarry256[122],xaddcarry256[121],xaddcarry256[120],xaddcarry256[119],xaddcarry256[118],xaddcarry256[117],xaddcarry256[116],xaddcarry256[115],xaddcarry256[114],xaddcarry256[113],xaddcarry256[112],xaddcarry256[111],xaddcarry256[110],xaddcarry256[109],xaddcarry256[108],xaddcarry256[107],xaddcarry256[106],xaddcarry256[105],xaddcarry256[104],xaddcarry256[103],xaddcarry256[102],xaddcarry256[101],xaddcarry256[100],xaddcarry256[99],xaddcarry256[98],xaddcarry256[97],xaddcarry256[96],xaddcarry256[95],xaddcarry256[94],xaddcarry256[93],xaddcarry256[92],xaddcarry256[91],xaddcarry256[90],xaddcarry256[89],xaddcarry256[88],xaddcarry256[87],xaddcarry256[86],xaddcarry256[85],xaddcarry256[84],xaddcarry256[83],xaddcarry256[82],xaddcarry256[81],xaddcarry256[80],xaddcarry256[79],xaddcarry256[78],xaddcarry256[77],xaddcarry256[76],xaddcarry256[75],xaddcarry256[74],xaddcarry256[73],xaddcarry256[72],xaddcarry256[71],xaddcarry256[70],xaddcarry256[69],xaddcarry256[68],xaddcarry256[67],xaddcarry256[66],xaddcarry256[65],xaddcarry256[64],xaddcarry256[63],xaddcarry256[62],xaddcarry256[61],xaddcarry256[60],xaddcarry256[59],xaddcarry256[58],xaddcarry256[57],xaddcarry256[56],xaddcarry256[55],xaddcarry256[54],xaddcarry256[53],xaddcarry256[52],xaddcarry256[51],xaddcarry256[50],xaddcarry256[49],xaddcarry256[48],xaddcarry256[47],xaddcarry256[46],xaddcarry256[45],xaddcarry256[44],xaddcarry256[43],xaddcarry256[42],xaddcarry256[41],xaddcarry256[40],xaddcarry256[39],xaddcarry256[38],xaddcarry256[37],xaddcarry256[36],xaddcarry256[35],xaddcarry256[34],xaddcarry256[33],xaddcarry256[32],xaddcarry256[31],xaddcarry256[30],xaddcarry256[29],xaddcarry256[28],xaddcarry256[27],xaddcarry256[26],xaddcarry256[25],xaddcarry256[24],xaddcarry256[23],xaddcarry256[22],xaddcarry256[21],xaddcarry256[20],xaddcarry256[19],xaddcarry256[18],xaddcarry256[17],xaddcarry256[16],xaddcarry256[15],xaddcarry256[14],xaddcarry256[13],xaddcarry256[12],xaddcarry256[11],xaddcarry256[10],xaddcarry256[9],xaddcarry256[8],xaddcarry256[7],xaddcarry256[6],xaddcarry256[5],xaddcarry256[4],xaddcarry256[3],xaddcarry256[2],xaddcarry256[1],xaddcarry256[0] -  fah_1  IS MISSING !!!!
*  p1 -  lab_pin  IS MISSING !!!!
*  p2 -  lab_pin  IS MISSING !!!!
*  p3 -  lab_pin  IS MISSING !!!!
*  p5 -  lab_pin  IS MISSING !!!!
*  p6 -  lab_pin  IS MISSING !!!!
*  p7 -  lab_pin  IS MISSING !!!!
*  p8 -  lab_pin  IS MISSING !!!!
*  p4 -  lab_pin  IS MISSING !!!!
*  p9 -  lab_pin  IS MISSING !!!!
*  xadd256 -  adder_256bit  IS MISSING !!!!
?
*  l1 -  vdd  IS MISSING !!!!
*  l3 -  noconn  IS MISSING !!!!
*  l4 -  gnd  IS MISSING !!!!
*  l5 -  noconn  IS MISSING !!!!
*  h2 -  launcher  IS MISSING !!!!
*  p10 -  spice_probe  IS MISSING !!!!
*  p14 -  spice_probe  IS MISSING !!!!
*  p15 -  spice_probe  IS MISSING !!!!
*  p16 -  spice_probe  IS MISSING !!!!
*  p17 -  spice_probe  IS MISSING !!!!
*  p18 -  spice_probe  IS MISSING !!!!
*  p19 -  spice_probe  IS MISSING !!!!
*  p20 -  spice_probe  IS MISSING !!!!
*
*+  C7[255],C7[254],C7[253],C7[252],C7[251],C7[250],C7[249],C7[248],C7[247],C7[246],C7[245],C7[244],C7[243],C7[242],C7[241],C7[240],C7[239],C7[238],C7[237],C7[236],C7[235],C7[234],C7[233],C7[232],C7[231],C7[230],C7[229],C7[228],C7[227],C7[226],C7[225],C7[224],C7[223],C7[222],C7[221],C7[220],C7[219],C7[218],C7[217],C7[216],C7[215],C7[214],C7[213],C7[212],C7[211],C7[210],C7[209],C7[208],C7[207],C7[206],C7[205],C7[204],C7[203],C7[202],C7[201],C7[200],C7[199],C7[198],C7[197],C7[196],C7[195],C7[194],C7[193],C7[192],C7[191],C7[190],C7[189],C7[188],C7[187],C7[186],C7[185],C7[184],C7[183],C7[182],C7[181],C7[180],C7[179],C7[178],C7[177],C7[176],C7[175],C7[174],C7[173],C7[172],C7[171],C7[170],C7[169],C7[168],C7[167],C7[166],C7[165],C7[164],C7[163],C7[162],C7[161],C7[160],C7[159],C7[158],C7[157],C7[156],C7[155],C7[154],C7[153],C7[152],C7[151],C7[150],C7[149],C7[148],C7[147],C7[146],C7[145],C7[144],C7[143],C7[142],C7[141],C7[140],C7[139],C7[138],C7[137],C7[136],C7[135],C7[134],C7[133],C7[132],C7[131],C7[130],C7[129],C7[128],C7[127],C7[126],C7[125],C7[124],C7[123],C7[122],C7[121],C7[120],C7[119],C7[118],C7[117],C7[116],C7[115],C7[114],C7[113],C7[112],C7[111],C7[110],C7[109],C7[108],C7[107],C7[106],C7[105],C7[104],C7[103],C7[102],C7[101],C7[100],C7[99],C7[98],C7[97],C7[96],C7[95],C7[94],C7[93],C7[92],C7[91],C7[90],C7[89],C7[88],C7[87],C7[86],C7[85],C7[84],C7[83],C7[82],C7[81],C7[80],C7[79],C7[78],C7[77],C7[76],C7[75],C7[74],C7[73],C7[72],C7[71],C7[70],C7[69],C7[68],C7[67],C7[66],C7[65],C7[64],C7[63],C7[62],C7[61],C7[60],C7[59],C7[58],C7[57],C7[56],C7[55],C7[54],C7[53],C7[52],C7[51],C7[50],C7[49],C7[48],C7[47],C7[46],C7[45],C7[44],C7[43],C7[42],C7[41],C7[40],C7[39],C7[38],C7[37],C7[36],C7[35],C7[34],C7[33],C7[32],C7[31],C7[30],C7[29],C7[28],C7[27],C7[26],C7[25],C7[24],C7[23],C7[22],C7[21],C7[20],C7[19],C7[18],C7[17],C7[16],C7[15],C7[14],C7[13],C7[12],C7[11],C7[10],C7[9],C7[8],C7[7],C7[6],C7[5],C7[4],C7[3],C7[2],C7[1],C7[0] -  parax_cap  IS MISSING !!!!
*
*+  C8[255],C8[254],C8[253],C8[252],C8[251],C8[250],C8[249],C8[248],C8[247],C8[246],C8[245],C8[244],C8[243],C8[242],C8[241],C8[240],C8[239],C8[238],C8[237],C8[236],C8[235],C8[234],C8[233],C8[232],C8[231],C8[230],C8[229],C8[228],C8[227],C8[226],C8[225],C8[224],C8[223],C8[222],C8[221],C8[220],C8[219],C8[218],C8[217],C8[216],C8[215],C8[214],C8[213],C8[212],C8[211],C8[210],C8[209],C8[208],C8[207],C8[206],C8[205],C8[204],C8[203],C8[202],C8[201],C8[200],C8[199],C8[198],C8[197],C8[196],C8[195],C8[194],C8[193],C8[192],C8[191],C8[190],C8[189],C8[188],C8[187],C8[186],C8[185],C8[184],C8[183],C8[182],C8[181],C8[180],C8[179],C8[178],C8[177],C8[176],C8[175],C8[174],C8[173],C8[172],C8[171],C8[170],C8[169],C8[168],C8[167],C8[166],C8[165],C8[164],C8[163],C8[162],C8[161],C8[160],C8[159],C8[158],C8[157],C8[156],C8[155],C8[154],C8[153],C8[152],C8[151],C8[150],C8[149],C8[148],C8[147],C8[146],C8[145],C8[144],C8[143],C8[142],C8[141],C8[140],C8[139],C8[138],C8[137],C8[136],C8[135],C8[134],C8[133],C8[132],C8[131],C8[130],C8[129],C8[128],C8[127],C8[126],C8[125],C8[124],C8[123],C8[122],C8[121],C8[120],C8[119],C8[118],C8[117],C8[116],C8[115],C8[114],C8[113],C8[112],C8[111],C8[110],C8[109],C8[108],C8[107],C8[106],C8[105],C8[104],C8[103],C8[102],C8[101],C8[100],C8[99],C8[98],C8[97],C8[96],C8[95],C8[94],C8[93],C8[92],C8[91],C8[90],C8[89],C8[88],C8[87],C8[86],C8[85],C8[84],C8[83],C8[82],C8[81],C8[80],C8[79],C8[78],C8[77],C8[76],C8[75],C8[74],C8[73],C8[72],C8[71],C8[70],C8[69],C8[68],C8[67],C8[66],C8[65],C8[64],C8[63],C8[62],C8[61],C8[60],C8[59],C8[58],C8[57],C8[56],C8[55],C8[54],C8[53],C8[52],C8[51],C8[50],C8[49],C8[48],C8[47],C8[46],C8[45],C8[44],C8[43],C8[42],C8[41],C8[40],C8[39],C8[38],C8[37],C8[36],C8[35],C8[34],C8[33],C8[32],C8[31],C8[30],C8[29],C8[28],C8[27],C8[26],C8[25],C8[24],C8[23],C8[22],C8[21],C8[20],C8[19],C8[18],C8[17],C8[16],C8[15],C8[14],C8[13],C8[12],C8[11],C8[10],C8[9],C8[8],C8[7],C8[6],C8[5],C8[4],C8[3],C8[2],C8[1],C8[0] -  parax_cap  IS MISSING !!!!
*  CORNER -  corner  IS MISSING !!!!
*  xadd32 -  adder_32bit  IS MISSING !!!!
*  p24 -  lab_pin  IS MISSING !!!!
*  p25 -  lab_pin  IS MISSING !!!!
*  p26 -  lab_pin  IS MISSING !!!!
*  p27 -  lab_pin  IS MISSING !!!!
*  p28 -  lab_pin  IS MISSING !!!!
*  p29 -  lab_pin  IS MISSING !!!!
*  p30 -  lab_pin  IS MISSING !!!!
*  p31 -  spice_probe  IS MISSING !!!!
*  p32 -  lab_pin  IS MISSING !!!!
*  p33 -  lab_pin  IS MISSING !!!!
*  p34 -  lab_pin  IS MISSING !!!!
*
*+  xaddcarry32[31],xaddcarry32[30],xaddcarry32[29],xaddcarry32[28],xaddcarry32[27],xaddcarry32[26],xaddcarry32[25],xaddcarry32[24],xaddcarry32[23],xaddcarry32[22],xaddcarry32[21],xaddcarry32[20],xaddcarry32[19],xaddcarry32[18],xaddcarry32[17],xaddcarry32[16],xaddcarry32[15],xaddcarry32[14],xaddcarry32[13],xaddcarry32[12],xaddcarry32[11],xaddcarry32[10],xaddcarry32[9],xaddcarry32[8],xaddcarry32[7],xaddcarry32[6],xaddcarry32[5],xaddcarry32[4],xaddcarry32[3],xaddcarry32[2],xaddcarry32[1],xaddcarry32[0] -  fah_1  IS MISSING !!!!
*  p35 -  lab_pin  IS MISSING !!!!
*  p36 -  lab_pin  IS MISSING !!!!
*  p37 -  spice_probe  IS MISSING !!!!
*  p38 -  spice_probe  IS MISSING !!!!
*  p39 -  spice_probe  IS MISSING !!!!
*
*+  C2[255],C2[254],C2[253],C2[252],C2[251],C2[250],C2[249],C2[248],C2[247],C2[246],C2[245],C2[244],C2[243],C2[242],C2[241],C2[240],C2[239],C2[238],C2[237],C2[236],C2[235],C2[234],C2[233],C2[232],C2[231],C2[230],C2[229],C2[228],C2[227],C2[226],C2[225],C2[224],C2[223],C2[222],C2[221],C2[220],C2[219],C2[218],C2[217],C2[216],C2[215],C2[214],C2[213],C2[212],C2[211],C2[210],C2[209],C2[208],C2[207],C2[206],C2[205],C2[204],C2[203],C2[202],C2[201],C2[200],C2[199],C2[198],C2[197],C2[196],C2[195],C2[194],C2[193],C2[192],C2[191],C2[190],C2[189],C2[188],C2[187],C2[186],C2[185],C2[184],C2[183],C2[182],C2[181],C2[180],C2[179],C2[178],C2[177],C2[176],C2[175],C2[174],C2[173],C2[172],C2[171],C2[170],C2[169],C2[168],C2[167],C2[166],C2[165],C2[164],C2[163],C2[162],C2[161],C2[160],C2[159],C2[158],C2[157],C2[156],C2[155],C2[154],C2[153],C2[152],C2[151],C2[150],C2[149],C2[148],C2[147],C2[146],C2[145],C2[144],C2[143],C2[142],C2[141],C2[140],C2[139],C2[138],C2[137],C2[136],C2[135],C2[134],C2[133],C2[132],C2[131],C2[130],C2[129],C2[128],C2[127],C2[126],C2[125],C2[124],C2[123],C2[122],C2[121],C2[120],C2[119],C2[118],C2[117],C2[116],C2[115],C2[114],C2[113],C2[112],C2[111],C2[110],C2[109],C2[108],C2[107],C2[106],C2[105],C2[104],C2[103],C2[102],C2[101],C2[100],C2[99],C2[98],C2[97],C2[96],C2[95],C2[94],C2[93],C2[92],C2[91],C2[90],C2[89],C2[88],C2[87],C2[86],C2[85],C2[84],C2[83],C2[82],C2[81],C2[80],C2[79],C2[78],C2[77],C2[76],C2[75],C2[74],C2[73],C2[72],C2[71],C2[70],C2[69],C2[68],C2[67],C2[66],C2[65],C2[64],C2[63],C2[62],C2[61],C2[60],C2[59],C2[58],C2[57],C2[56],C2[55],C2[54],C2[53],C2[52],C2[51],C2[50],C2[49],C2[48],C2[47],C2[46],C2[45],C2[44],C2[43],C2[42],C2[41],C2[40],C2[39],C2[38],C2[37],C2[36],C2[35],C2[34],C2[33],C2[32],C2[31],C2[30],C2[29],C2[28],C2[27],C2[26],C2[25],C2[24],C2[23],C2[22],C2[21],C2[20],C2[19],C2[18],C2[17],C2[16],C2[15],C2[14],C2[13],C2[12],C2[11],C2[10],C2[9],C2[8],C2[7],C2[6],C2[5],C2[4],C2[3],C2[2],C2[1],C2[0] -  parax_cap  IS MISSING !!!!
*
*+  C3[255],C3[254],C3[253],C3[252],C3[251],C3[250],C3[249],C3[248],C3[247],C3[246],C3[245],C3[244],C3[243],C3[242],C3[241],C3[240],C3[239],C3[238],C3[237],C3[236],C3[235],C3[234],C3[233],C3[232],C3[231],C3[230],C3[229],C3[228],C3[227],C3[226],C3[225],C3[224],C3[223],C3[222],C3[221],C3[220],C3[219],C3[218],C3[217],C3[216],C3[215],C3[214],C3[213],C3[212],C3[211],C3[210],C3[209],C3[208],C3[207],C3[206],C3[205],C3[204],C3[203],C3[202],C3[201],C3[200],C3[199],C3[198],C3[197],C3[196],C3[195],C3[194],C3[193],C3[192],C3[191],C3[190],C3[189],C3[188],C3[187],C3[186],C3[185],C3[184],C3[183],C3[182],C3[181],C3[180],C3[179],C3[178],C3[177],C3[176],C3[175],C3[174],C3[173],C3[172],C3[171],C3[170],C3[169],C3[168],C3[167],C3[166],C3[165],C3[164],C3[163],C3[162],C3[161],C3[160],C3[159],C3[158],C3[157],C3[156],C3[155],C3[154],C3[153],C3[152],C3[151],C3[150],C3[149],C3[148],C3[147],C3[146],C3[145],C3[144],C3[143],C3[142],C3[141],C3[140],C3[139],C3[138],C3[137],C3[136],C3[135],C3[134],C3[133],C3[132],C3[131],C3[130],C3[129],C3[128],C3[127],C3[126],C3[125],C3[124],C3[123],C3[122],C3[121],C3[120],C3[119],C3[118],C3[117],C3[116],C3[115],C3[114],C3[113],C3[112],C3[111],C3[110],C3[109],C3[108],C3[107],C3[106],C3[105],C3[104],C3[103],C3[102],C3[101],C3[100],C3[99],C3[98],C3[97],C3[96],C3[95],C3[94],C3[93],C3[92],C3[91],C3[90],C3[89],C3[88],C3[87],C3[86],C3[85],C3[84],C3[83],C3[82],C3[81],C3[80],C3[79],C3[78],C3[77],C3[76],C3[75],C3[74],C3[73],C3[72],C3[71],C3[70],C3[69],C3[68],C3[67],C3[66],C3[65],C3[64],C3[63],C3[62],C3[61],C3[60],C3[59],C3[58],C3[57],C3[56],C3[55],C3[54],C3[53],C3[52],C3[51],C3[50],C3[49],C3[48],C3[47],C3[46],C3[45],C3[44],C3[43],C3[42],C3[41],C3[40],C3[39],C3[38],C3[37],C3[36],C3[35],C3[34],C3[33],C3[32],C3[31],C3[30],C3[29],C3[28],C3[27],C3[26],C3[25],C3[24],C3[23],C3[22],C3[21],C3[20],C3[19],C3[18],C3[17],C3[16],C3[15],C3[14],C3[13],C3[12],C3[11],C3[10],C3[9],C3[8],C3[7],C3[6],C3[5],C3[4],C3[3],C3[2],C3[1],C3[0] -  parax_cap  IS MISSING !!!!
*  C6 -  parax_cap  IS MISSING !!!!
*  C1 -  parax_cap  IS MISSING !!!!
*  COMMANDS2 -  simulator_commands  IS MISSING !!!!
*  NGSPICE -  simulator_commands  IS MISSING !!!!
*
*+  C4[31],C4[30],C4[29],C4[28],C4[27],C4[26],C4[25],C4[24],C4[23],C4[22],C4[21],C4[20],C4[19],C4[18],C4[17],C4[16],C4[15],C4[14],C4[13],C4[12],C4[11],C4[10],C4[9],C4[8],C4[7],C4[6],C4[5],C4[4],C4[3],C4[2],C4[1],C4[0] -  parax_cap  IS MISSING !!!!
*
*+  C5[31],C5[30],C5[29],C5[28],C5[27],C5[26],C5[25],C5[24],C5[23],C5[22],C5[21],C5[20],C5[19],C5[18],C5[17],C5[16],C5[15],C5[14],C5[13],C5[12],C5[11],C5[10],C5[9],C5[8],C5[7],C5[6],C5[5],C5[4],C5[3],C5[2],C5[1],C5[0] -  parax_cap  IS MISSING !!!!
*  h1 -  launcher  IS MISSING !!!!
*  h3 -  launcher  IS MISSING !!!!
**** begin user architecture code

**** end user architecture code
.ends
