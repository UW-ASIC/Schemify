** sch_path: /home/omare/Documents/UWASIC/Schemify/test/examples/xschem_sky130/sky130_tests/charge_pump_ideal.sch
.subckt charge_pump_ideal VCC HV CK CKN

*  l1 -  title  IS MISSING !!!!
*  p24 -  ipin  IS MISSING !!!!
*  p25 -  ipin  IS MISSING !!!!
*  X4 -  diode_ngspice  IS MISSING !!!!
*  X5 -  diode_ngspice  IS MISSING !!!!
*  X6 -  diode_ngspice  IS MISSING !!!!
*  C1 -  capa  IS MISSING !!!!
*  C2 -  capa  IS MISSING !!!!
*  p21 -  iopin  IS MISSING !!!!
*  p20 -  ipin  IS MISSING !!!!
.ends
