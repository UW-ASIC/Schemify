** sch_path: /home/omare/Documents/UWASIC/Schemify/test/examples/xschem_sky130/xschem_verilog_import/counter.sch
.subckt counter VGND VPWR clk_i reset_i

*  p67 -  ipin  IS MISSING !!!!
*  p68 -  ipin  IS MISSING !!!!
*  p69 -  ipin  IS MISSING !!!!
*  p70 -  ipin  IS MISSING !!!!
*  p71 -  opin  IS MISSING !!!!
*  XFILLER_0_19 -  decap_8  IS MISSING !!!!
*  XFILLER_0_27 -  fill_1  IS MISSING !!!!
*  XFILLER_0_29 -  decap_8  IS MISSING !!!!
*  XFILLER_0_37 -  fill_2  IS MISSING !!!!
*  XFILLER_0_43 -  decap_4  IS MISSING !!!!
*  XFILLER_0_7 -  decap_12  IS MISSING !!!!
*  XFILLER_10_15 -  decap_12  IS MISSING !!!!
*  XFILLER_10_27 -  fill_1  IS MISSING !!!!
*  XFILLER_10_29 -  decap_12  IS MISSING !!!!
*  XFILLER_10_3 -  decap_12  IS MISSING !!!!
*  XFILLER_10_41 -  decap_6  IS MISSING !!!!
*  XFILLER_11_19 -  decap_8  IS MISSING !!!!
*  XFILLER_11_27 -  fill_1  IS MISSING !!!!
*  XFILLER_11_29 -  decap_8  IS MISSING !!!!
*  XFILLER_11_37 -  fill_2  IS MISSING !!!!
*  XFILLER_11_43 -  decap_4  IS MISSING !!!!
*  XFILLER_11_7 -  decap_12  IS MISSING !!!!
*  XFILLER_1_15 -  decap_12  IS MISSING !!!!
*  XFILLER_1_27 -  decap_12  IS MISSING !!!!
*  XFILLER_1_3 -  decap_12  IS MISSING !!!!
*  XFILLER_1_39 -  fill_1  IS MISSING !!!!
*  XFILLER_1_43 -  decap_4  IS MISSING !!!!
*  XFILLER_2_11 -  fill_2  IS MISSING !!!!
*  XFILLER_2_17 -  decap_8  IS MISSING !!!!
*  XFILLER_2_25 -  decap_3  IS MISSING !!!!
*  XFILLER_2_3 -  decap_8  IS MISSING !!!!
*  XFILLER_2_32 -  decap_4  IS MISSING !!!!
*  XFILLER_2_39 -  decap_8  IS MISSING !!!!
*  XFILLER_3_14 -  decap_6  IS MISSING !!!!
*  XFILLER_3_23 -  decap_4  IS MISSING !!!!
*  XFILLER_3_3 -  decap_6  IS MISSING !!!!
*  XFILLER_3_43 -  decap_4  IS MISSING !!!!
*  XFILLER_3_9 -  fill_1  IS MISSING !!!!
*  XFILLER_4_21 -  decap_6  IS MISSING !!!!
*  XFILLER_4_27 -  fill_1  IS MISSING !!!!
*  XFILLER_4_3 -  fill_2  IS MISSING !!!!
*  XFILLER_4_38 -  decap_8  IS MISSING !!!!
*  XFILLER_4_46 -  fill_1  IS MISSING !!!!
*  XFILLER_5_16 -  decap_4  IS MISSING !!!!
*  XFILLER_5_3 -  decap_6  IS MISSING !!!!
*  XFILLER_5_40 -  decap_6  IS MISSING !!!!
*  XFILLER_5_46 -  fill_1  IS MISSING !!!!
*  XFILLER_5_9 -  fill_1  IS MISSING !!!!
*  XFILLER_6_24 -  decap_4  IS MISSING !!!!
*  XFILLER_6_3 -  decap_4  IS MISSING !!!!
*  XFILLER_6_38 -  decap_8  IS MISSING !!!!
*  XFILLER_6_46 -  fill_1  IS MISSING !!!!
*  XFILLER_6_7 -  fill_1  IS MISSING !!!!
*  XFILLER_7_14 -  decap_4  IS MISSING !!!!
*  XFILLER_7_3 -  decap_8  IS MISSING !!!!
*  XFILLER_7_34 -  decap_4  IS MISSING !!!!
*  XFILLER_7_43 -  decap_4  IS MISSING !!!!
*  XFILLER_8_13 -  decap_12  IS MISSING !!!!
*  XFILLER_8_25 -  decap_3  IS MISSING !!!!
*  XFILLER_8_3 -  decap_6  IS MISSING !!!!
*  XFILLER_8_32 -  decap_6  IS MISSING !!!!
*  XFILLER_8_42 -  decap_4  IS MISSING !!!!
*  XFILLER_8_46 -  fill_1  IS MISSING !!!!
*  XFILLER_8_9 -  fill_1  IS MISSING !!!!
*  XFILLER_9_15 -  decap_12  IS MISSING !!!!
*  XFILLER_9_27 -  decap_8  IS MISSING !!!!
*  XFILLER_9_3 -  decap_12  IS MISSING !!!!
*  XFILLER_9_35 -  fill_1  IS MISSING !!!!
*  XFILLER_9_39 -  decap_8  IS MISSING !!!!
*  XPHY_0 -  decap_3  IS MISSING !!!!
*  XPHY_1 -  decap_3  IS MISSING !!!!
*  XPHY_10 -  decap_3  IS MISSING !!!!
*  XPHY_11 -  decap_3  IS MISSING !!!!
*  XPHY_12 -  decap_3  IS MISSING !!!!
*  XPHY_13 -  decap_3  IS MISSING !!!!
*  XPHY_14 -  decap_3  IS MISSING !!!!
*  XPHY_15 -  decap_3  IS MISSING !!!!
*  XPHY_16 -  decap_3  IS MISSING !!!!
*  XPHY_17 -  decap_3  IS MISSING !!!!
*  XPHY_18 -  decap_3  IS MISSING !!!!
*  XPHY_19 -  decap_3  IS MISSING !!!!
*  XPHY_2 -  decap_3  IS MISSING !!!!
*  XPHY_20 -  decap_3  IS MISSING !!!!
*  XPHY_21 -  decap_3  IS MISSING !!!!
*  XPHY_22 -  decap_3  IS MISSING !!!!
*  XPHY_23 -  decap_3  IS MISSING !!!!
*  XPHY_3 -  decap_3  IS MISSING !!!!
*  XPHY_4 -  decap_3  IS MISSING !!!!
*  XPHY_5 -  decap_3  IS MISSING !!!!
*  XPHY_6 -  decap_3  IS MISSING !!!!
*  XPHY_7 -  decap_3  IS MISSING !!!!
*  XPHY_8 -  decap_3  IS MISSING !!!!
*  XPHY_9 -  decap_3  IS MISSING !!!!
*  XTAP_24 -  tapvpwrvgnd_1  IS MISSING !!!!
*  XTAP_25 -  tapvpwrvgnd_1  IS MISSING !!!!
*  XTAP_26 -  tapvpwrvgnd_1  IS MISSING !!!!
*  XTAP_27 -  tapvpwrvgnd_1  IS MISSING !!!!
*  XTAP_28 -  tapvpwrvgnd_1  IS MISSING !!!!
*  XTAP_29 -  tapvpwrvgnd_1  IS MISSING !!!!
*  XTAP_30 -  tapvpwrvgnd_1  IS MISSING !!!!
*  p0 -  lab_pin  IS MISSING !!!!
*  p1 -  lab_pin  IS MISSING !!!!
*  X_12_ -  inv_2  IS MISSING !!!!
*  p2 -  lab_pin  IS MISSING !!!!
*  p3 -  lab_pin  IS MISSING !!!!
*  X_13_ -  inv_2  IS MISSING !!!!
*  p4 -  lab_pin  IS MISSING !!!!
*  p5 -  lab_pin  IS MISSING !!!!
*  X_14_ -  inv_2  IS MISSING !!!!
*  p6 -  lab_pin  IS MISSING !!!!
*  p7 -  lab_pin  IS MISSING !!!!
*  p8 -  lab_pin  IS MISSING !!!!
*  p9 -  lab_pin  IS MISSING !!!!
*  X_15_ -  or3_1  IS MISSING !!!!
*  p10 -  lab_pin  IS MISSING !!!!
*  p11 -  lab_pin  IS MISSING !!!!
*  X_16_ -  inv_2  IS MISSING !!!!
*  p12 -  lab_pin  IS MISSING !!!!
*  p13 -  lab_pin  IS MISSING !!!!
*  p14 -  lab_pin  IS MISSING !!!!
*  p15 -  lab_pin  IS MISSING !!!!
*  X_17_ -  o21a_1  IS MISSING !!!!
*  p16 -  lab_pin  IS MISSING !!!!
*  p17 -  lab_pin  IS MISSING !!!!
*  p18 -  lab_pin  IS MISSING !!!!
*  p19 -  lab_pin  IS MISSING !!!!
*  X_18_ -  nor3_1  IS MISSING !!!!
*  p20 -  lab_pin  IS MISSING !!!!
*  p21 -  lab_pin  IS MISSING !!!!
*  X_19_ -  inv_2  IS MISSING !!!!
*  p22 -  lab_pin  IS MISSING !!!!
*  p23 -  lab_pin  IS MISSING !!!!
*  p24 -  lab_pin  IS MISSING !!!!
*  p25 -  lab_pin  IS MISSING !!!!
*  p26 -  lab_pin  IS MISSING !!!!
*  p27 -  lab_pin  IS MISSING !!!!
*  X_20_ -  o221a_1  IS MISSING !!!!
*  p28 -  lab_pin  IS MISSING !!!!
*  p29 -  lab_pin  IS MISSING !!!!
*  p30 -  lab_pin  IS MISSING !!!!
*  X_21_ -  nor2_1  IS MISSING !!!!
*  p31 -  lab_pin  IS MISSING !!!!
*  p32 -  lab_pin  IS MISSING !!!!
*  X_22_ -  inv_2  IS MISSING !!!!
*  p33 -  lab_pin  IS MISSING !!!!
*  p34 -  lab_pin  IS MISSING !!!!
*  p35 -  lab_pin  IS MISSING !!!!
*  p36 -  lab_pin  IS MISSING !!!!
*  p37 -  lab_pin  IS MISSING !!!!
*  p38 -  lab_pin  IS MISSING !!!!
*  X_23_ -  o221a_1  IS MISSING !!!!
*  p39 -  lab_pin  IS MISSING !!!!
*  p40 -  lab_pin  IS MISSING !!!!
*  p41 -  lab_pin  IS MISSING !!!!
*  X_24_ -  dfxtp_1  IS MISSING !!!!
*  p42 -  lab_pin  IS MISSING !!!!
*  p43 -  lab_pin  IS MISSING !!!!
*  p44 -  lab_pin  IS MISSING !!!!
*  X_25_ -  dfxtp_1  IS MISSING !!!!
*  p45 -  lab_pin  IS MISSING !!!!
*  p46 -  lab_pin  IS MISSING !!!!
*  p47 -  lab_pin  IS MISSING !!!!
*  X_26_ -  dfxtp_1  IS MISSING !!!!
*  p48 -  lab_pin  IS MISSING !!!!
*  p49 -  lab_pin  IS MISSING !!!!
*  p50 -  lab_pin  IS MISSING !!!!
*  X_27_ -  dfxtp_1  IS MISSING !!!!
*  p51 -  lab_pin  IS MISSING !!!!
*  p52 -  lab_pin  IS MISSING !!!!
*  Xclkbuf_0_clk_i -  clkbuf_16  IS MISSING !!!!
*  p53 -  lab_pin  IS MISSING !!!!
*  p54 -  lab_pin  IS MISSING !!!!
*  Xclkbuf_1_0_0_clk_i -  clkbuf_2  IS MISSING !!!!
*  p55 -  lab_pin  IS MISSING !!!!
*  p56 -  lab_pin  IS MISSING !!!!
*  Xclkbuf_1_1_0_clk_i -  clkbuf_2  IS MISSING !!!!
*  p57 -  lab_pin  IS MISSING !!!!
*  p58 -  lab_pin  IS MISSING !!!!
*  Xinput1 -  clkbuf_1  IS MISSING !!!!
*  p59 -  lab_pin  IS MISSING !!!!
*  p60 -  lab_pin  IS MISSING !!!!
*  Xoutput2 -  buf_2  IS MISSING !!!!
*  p61 -  lab_pin  IS MISSING !!!!
*  p62 -  lab_pin  IS MISSING !!!!
*  Xoutput3 -  buf_2  IS MISSING !!!!
*  p63 -  lab_pin  IS MISSING !!!!
*  p64 -  lab_pin  IS MISSING !!!!
*  Xoutput4 -  buf_2  IS MISSING !!!!
*  p65 -  lab_pin  IS MISSING !!!!
*  p66 -  lab_pin  IS MISSING !!!!
*  Xoutput5 -  buf_2  IS MISSING !!!!
.ends
