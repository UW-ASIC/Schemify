** sch_path: /nix/store/qriw4afhakn3sqg2al06kdyr745hx86w-xschem-3.4.7/share/doc/xschem/examples/mos_power_ampli.sch
.subckt mos_power_ampli MINUS PLUS VSS OUT VPP VNN
*.PININFO PLUS:I VNN:I OUT:O MINUS:I VSS:I VPP:I
xm2 net1 GB SB irf540 m=1
R7 GB SB 320 m=1
xm1 VPP GA SA irf540 m=1
R0 GA SA 320 m=1
R2 VPP E2 50 m=1
R3 VBOOST E1 50 m=1
Q5 C5 PLUS E9 q2n2222 area=1 m=1
Q4 net8 net2 E4 q2n2907p area=1 m=1
R9 VBOOST E4 50 m=1
Q6 C6 C2 net5 q2n2907p area=1 m=1
R4 VPP E6 50 m=1
vd OUTI net1 0
.save i(vd)
vu SA OUTI 0
.save i(vu)
Q1 net2 net2 E1 q2n2907p area=1 m=1
Q2 C2 C2 net4 q2n2907p area=1 m=1
Q9 C9 MINUS E9 q2n2222 area=1 m=1
R11 GB net6 1000 m=1
Q8 C8 VSS E8 q2n2907p area=1 m=1
C12 VBOOST net3 40u m=1
D0 VPP VBOOST d1n4148 area=1
R18 net3 OUTI 200 m=1
D1 VPP VBOOST d1n758
R14 B1 net7 4k m=1
Q11 GA B1 E11 q2n2907p area=1 m=1
R15 VBOOST B1 4k m=1
R5 E9 net9 40 m=1
R6 net9 net10 40 m=1
D2 VSS B3 1N746
Q3 C3 B3 E3 q2n2222 area=1 m=1
R1 VPP B3 7k m=1
R10 E3 VSS 110 m=1
C3 B3 VSS 100n m=1
R12 C6 E8 400 m=1
R13 C2 C9 300 m=1
Q7 C7 C9 C5 q2n2222 area=1 m=1
v0 SB VNN 0
.save i(v0)
v1 E6 net5 0
.save i(v1)
v2 E2 net4 0
.save i(v2)
v3 net10 C3 0
.save i(v3)
v4 C8 net6 0
.save i(v4)
v5 net7 OUTI 0
.save i(v5)
v6 net2 C7 0
.save i(v6)
v7 net8 E11 0
.save i(v7)
.save v(gb)
.save v(sb)
.save v(ga)
.save v(sa)
v8 OUTI OUT 0
.save i(v8)
.save v(ga)
.save v(gb)
.save v(c2)
.save v(net2)
.save v(c7)
.save v(vboost)
.save v(outi)
**** begin user architecture code

.option PARHIER=LOCAL RUNLVL=6 post MODMONTE=1 warn maxwarn=6000
.option sampling_method = SRS ingold=1
.option method=gear
.option savecurrents
.temp 30

vvss vss 0 dc 0
vvpp vpp 0 dc 50
vvnn vnn 0 dc -50

rfb1 vpp minus 100k
rfb2 out minus 100k
rfb3 minus vdc '100k/43'

vvdc vdc 0 dc 21.3
eref vref 0 plus vdc 45

vplus plus vdc dc 0

evboost vboost 0 vol='v(out)>=40 ? v(out)+10 : 50'
rload out 0 4

** models are generally not free: you must download
** SPICE models for active devices and put them  into the below
** referenced file in simulation directory.
.include "models_poweramp.txt"
.dc vplus '-1.5' '1.5' 0.1
.save all
.op
*.probe dc v(plus,vdc)

**** end user architecture code
.ends
