** sch_path: /home/omare/Documents/UWASIC/Schemify/test/examples/xschem_sky130/sky130_tests/srlatch.sch
.subckt srlatch S CLK R Q QN

*  l1 -  title  IS MISSING !!!!
*  STIMULI -  code  IS MISSING !!!!
*  p2 -  ipin  IS MISSING !!!!
*  p3 -  ipin  IS MISSING !!!!
*  p4 -  opin  IS MISSING !!!!
*  p5 -  opin  IS MISSING !!!!
*  p1 -  ipin  IS MISSING !!!!
*  l2 -  lab_wire  IS MISSING !!!!
*  l3 -  lab_wire  IS MISSING !!!!
*  x5 -  lvnand  IS MISSING !!!!
*  x1 -  lvnand  IS MISSING !!!!
*  x2 -  lvnand  IS MISSING !!!!
*  x3 -  lvnand  IS MISSING !!!!
?
.ends
