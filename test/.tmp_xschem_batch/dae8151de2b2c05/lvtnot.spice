** sch_path: /home/omare/Documents/UWASIC/Schemify/test/examples/xschem_sky130/sky130_tests/lvtnot.sch
.subckt lvtnot a y VCCPIN VSSPIN

*  p1 -  opin  IS MISSING !!!!
*  p2 -  ipin  IS MISSING !!!!
*  p149 -  lab_pin  IS MISSING !!!!
*  p3 -  lab_pin  IS MISSING !!!!
*  l3 -  title  IS MISSING !!!!
*  M2 -  pfet_01v8_lvt  IS MISSING !!!!
*  M1 -  nfet_01v8_lvt  IS MISSING !!!!
.ends
