** sch_path: /home/omare/Documents/UWASIC/Schemify/test/examples/xschem_sky130/sky130_tests/gates.sch
.subckt gates

*  x1 -  NAND2  IS MISSING !!!!
*  x2 -  NOR2  IS MISSING !!!!
*  x3 -  AOI21  IS MISSING !!!!
*  x4 -  DFFR  IS MISSING !!!!
*  x5 -  AND2  IS MISSING !!!!
*  x6 -  DFFIR  IS MISSING !!!!
*  x7 -  AND2I  IS MISSING !!!!
*  x8 -  AND3  IS MISSING !!!!
*  x9 -  AND4  IS MISSING !!!!
*  x10 -  AND5  IS MISSING !!!!
*  x11 -  AND8  IS MISSING !!!!
*  x12 -  NAND2I  IS MISSING !!!!
*  x13 -  NAND3  IS MISSING !!!!
*  x14 -  NAND4  IS MISSING !!!!
*  x15 -  NAND5  IS MISSING !!!!
*  x16 -  NAND8  IS MISSING !!!!
*  x17 -  AOI22  IS MISSING !!!!
*  x18 -  NOR3  IS MISSING !!!!
*  x19 -  NOR4  IS MISSING !!!!
*  x20 -  NOR5  IS MISSING !!!!
*  x21 -  NOR2I  IS MISSING !!!!
*  x22 -  NOR8  IS MISSING !!!!
*  x23 -  OAI21  IS MISSING !!!!
*  x24 -  OAI22  IS MISSING !!!!
*  x25 -  OR2  IS MISSING !!!!
*  x26 -  OR3  IS MISSING !!!!
*  x27 -  OR4  IS MISSING !!!!
*  x28 -  OR5  IS MISSING !!!!
*  x29 -  OR2I  IS MISSING !!!!
*  x30 -  OR8  IS MISSING !!!!
*  x31 -  AO21  IS MISSING !!!!
*  x32 -  AO22  IS MISSING !!!!
*  x33 -  OA21  IS MISSING !!!!
*  x34 -  OA22  IS MISSING !!!!
*  x35 -  INV  IS MISSING !!!!
*  x36 -  BUF  IS MISSING !!!!
*  x37 -  TBUF  IS MISSING !!!!
*  x39 -  TBUFI  IS MISSING !!!!
*  x38 -  MUX2  IS MISSING !!!!
*  x40 -  MUX2I  IS MISSING !!!!
*  x41 -  MUX4  IS MISSING !!!!
*  x42 -  MUX4I  IS MISSING !!!!
*  x43 -  HA  IS MISSING !!!!
*  x44 -  FA  IS MISSING !!!!
*  x45 -  DFF  IS MISSING !!!!
*  x46 -  DFFI  IS MISSING !!!!
*  x47 -  DFFIS  IS MISSING !!!!
*  x48 -  DFFS  IS MISSING !!!!
*  x49 -  DFFISR  IS MISSING !!!!
*  x50 -  DFFSR  IS MISSING !!!!
*  x51 -  DFFRQ  IS MISSING !!!!
*  x52 -  DFFIRQ  IS MISSING !!!!
*  x53 -  DFFQ  IS MISSING !!!!
*  x54 -  DFFIQ  IS MISSING !!!!
*  x55 -  DFFISQ  IS MISSING !!!!
*  x56 -  DFFSQ  IS MISSING !!!!
*  x57 -  DFFISRQ  IS MISSING !!!!
*  x58 -  DFFSRQ  IS MISSING !!!!
*  x59 -  XOR2  IS MISSING !!!!
*  x60 -  XNOR2  IS MISSING !!!!
*  x61 -  LATCH  IS MISSING !!!!
*  x63 -  LATCHIQ  IS MISSING !!!!
*  x64 -  LATCHIR  IS MISSING !!!!
*  x65 -  LATCHIRQ  IS MISSING !!!!
*  x66 -  LATCHQ  IS MISSING !!!!
*  x67 -  LATCHR  IS MISSING !!!!
*  x68 -  LATCHRQ  IS MISSING !!!!
*  x69 -  LATCHI  IS MISSING !!!!
*  x62 -  LATCHIS  IS MISSING !!!!
*  x70 -  LATCHISQ  IS MISSING !!!!
*  x71 -  LATCHS  IS MISSING !!!!
*  x72 -  LATCHSQ  IS MISSING !!!!
*  x73 -  EDFF  IS MISSING !!!!
*  x74 -  EDFFQ  IS MISSING !!!!
*  x75 -  SDFF  IS MISSING !!!!
*  x76 -  SDFFQ  IS MISSING !!!!
*  l1 -  title  IS MISSING !!!!
*  p1 -  lab_pin  IS MISSING !!!!
*  p2 -  lab_pin  IS MISSING !!!!
*  p3 -  lab_pin  IS MISSING !!!!
*  p4 -  lab_pin  IS MISSING !!!!
*  p5 -  lab_pin  IS MISSING !!!!
*  p6 -  lab_pin  IS MISSING !!!!
*  p7 -  lab_pin  IS MISSING !!!!
*  p8 -  lab_pin  IS MISSING !!!!
*  p9 -  lab_pin  IS MISSING !!!!
*  p10 -  lab_pin  IS MISSING !!!!
*  p11 -  lab_pin  IS MISSING !!!!
*  p12 -  lab_pin  IS MISSING !!!!
*  p13 -  lab_pin  IS MISSING !!!!
*  p14 -  lab_pin  IS MISSING !!!!
*  p15 -  lab_pin  IS MISSING !!!!
*  p16 -  lab_pin  IS MISSING !!!!
*  p17 -  lab_pin  IS MISSING !!!!
*  p18 -  lab_pin  IS MISSING !!!!
*  p19 -  lab_pin  IS MISSING !!!!
*  p20 -  lab_pin  IS MISSING !!!!
*  p21 -  lab_pin  IS MISSING !!!!
*  p22 -  lab_pin  IS MISSING !!!!
*  p23 -  lab_pin  IS MISSING !!!!
*  p24 -  lab_pin  IS MISSING !!!!
*  p25 -  lab_pin  IS MISSING !!!!
*  p26 -  lab_pin  IS MISSING !!!!
*  p27 -  lab_pin  IS MISSING !!!!
*  p28 -  lab_pin  IS MISSING !!!!
*  p29 -  lab_pin  IS MISSING !!!!
*  p30 -  lab_pin  IS MISSING !!!!
*  p31 -  lab_pin  IS MISSING !!!!
*  p32 -  lab_pin  IS MISSING !!!!
*  p33 -  lab_pin  IS MISSING !!!!
*  p34 -  lab_pin  IS MISSING !!!!
*  p35 -  lab_pin  IS MISSING !!!!
*  p36 -  lab_pin  IS MISSING !!!!
*  p37 -  lab_pin  IS MISSING !!!!
*  p38 -  lab_pin  IS MISSING !!!!
*  p39 -  lab_pin  IS MISSING !!!!
*  p40 -  lab_pin  IS MISSING !!!!
*  p41 -  lab_pin  IS MISSING !!!!
*  p42 -  lab_pin  IS MISSING !!!!
*  p43 -  lab_pin  IS MISSING !!!!
*  p44 -  lab_pin  IS MISSING !!!!
*  p45 -  lab_pin  IS MISSING !!!!
*  p46 -  lab_pin  IS MISSING !!!!
*  p47 -  lab_pin  IS MISSING !!!!
*  p48 -  lab_pin  IS MISSING !!!!
*  p49 -  lab_pin  IS MISSING !!!!
*  p50 -  lab_pin  IS MISSING !!!!
*  p51 -  lab_pin  IS MISSING !!!!
*  p52 -  lab_pin  IS MISSING !!!!
*  p53 -  lab_pin  IS MISSING !!!!
*  p54 -  lab_pin  IS MISSING !!!!
*  p55 -  lab_pin  IS MISSING !!!!
*  p56 -  lab_pin  IS MISSING !!!!
*  p57 -  lab_pin  IS MISSING !!!!
*  p58 -  lab_pin  IS MISSING !!!!
*  p59 -  lab_pin  IS MISSING !!!!
*  p60 -  lab_pin  IS MISSING !!!!
*  p61 -  lab_pin  IS MISSING !!!!
*  p62 -  lab_pin  IS MISSING !!!!
*  p63 -  lab_pin  IS MISSING !!!!
*  p64 -  lab_pin  IS MISSING !!!!
*  p65 -  lab_pin  IS MISSING !!!!
*  p66 -  lab_pin  IS MISSING !!!!
*  p67 -  lab_pin  IS MISSING !!!!
*  p68 -  lab_pin  IS MISSING !!!!
*  p69 -  lab_pin  IS MISSING !!!!
*  p70 -  lab_pin  IS MISSING !!!!
*  p71 -  lab_pin  IS MISSING !!!!
*  p72 -  lab_pin  IS MISSING !!!!
*  p73 -  lab_pin  IS MISSING !!!!
*  p74 -  lab_pin  IS MISSING !!!!
*  p75 -  lab_pin  IS MISSING !!!!
*  p76 -  lab_pin  IS MISSING !!!!
*  p77 -  lab_pin  IS MISSING !!!!
*  p78 -  lab_pin  IS MISSING !!!!
*  p79 -  lab_pin  IS MISSING !!!!
*  p80 -  lab_pin  IS MISSING !!!!
*  p81 -  lab_pin  IS MISSING !!!!
*  p82 -  lab_pin  IS MISSING !!!!
*  p83 -  lab_pin  IS MISSING !!!!
*  p84 -  lab_pin  IS MISSING !!!!
*  p85 -  lab_pin  IS MISSING !!!!
*  p86 -  lab_pin  IS MISSING !!!!
*  p87 -  lab_pin  IS MISSING !!!!
*  p88 -  lab_pin  IS MISSING !!!!
*  p89 -  lab_pin  IS MISSING !!!!
*  p90 -  lab_pin  IS MISSING !!!!
*  p91 -  lab_pin  IS MISSING !!!!
*  p92 -  lab_pin  IS MISSING !!!!
*  p93 -  lab_pin  IS MISSING !!!!
*  p94 -  lab_pin  IS MISSING !!!!
*  p95 -  lab_pin  IS MISSING !!!!
*  p96 -  lab_pin  IS MISSING !!!!
*  p97 -  lab_pin  IS MISSING !!!!
*  p98 -  lab_pin  IS MISSING !!!!
*  p99 -  lab_pin  IS MISSING !!!!
*  p100 -  lab_pin  IS MISSING !!!!
*  p101 -  lab_pin  IS MISSING !!!!
*  p102 -  lab_pin  IS MISSING !!!!
*  p103 -  lab_pin  IS MISSING !!!!
*  p104 -  lab_pin  IS MISSING !!!!
*  p105 -  lab_pin  IS MISSING !!!!
*  p106 -  lab_pin  IS MISSING !!!!
*  p107 -  lab_pin  IS MISSING !!!!
*  p108 -  lab_pin  IS MISSING !!!!
*  p109 -  lab_pin  IS MISSING !!!!
*  p110 -  lab_pin  IS MISSING !!!!
*  p111 -  lab_pin  IS MISSING !!!!
*  p112 -  lab_pin  IS MISSING !!!!
*  p113 -  lab_pin  IS MISSING !!!!
*  p114 -  lab_pin  IS MISSING !!!!
*  p115 -  lab_pin  IS MISSING !!!!
*  p116 -  lab_pin  IS MISSING !!!!
*  p117 -  lab_pin  IS MISSING !!!!
*  p118 -  lab_pin  IS MISSING !!!!
*  p119 -  lab_pin  IS MISSING !!!!
*  p120 -  lab_pin  IS MISSING !!!!
*  p121 -  lab_pin  IS MISSING !!!!
*  p122 -  lab_pin  IS MISSING !!!!
*  p123 -  lab_pin  IS MISSING !!!!
*  p124 -  lab_pin  IS MISSING !!!!
*  p125 -  lab_pin  IS MISSING !!!!
*  p126 -  lab_pin  IS MISSING !!!!
*  p127 -  lab_pin  IS MISSING !!!!
*  p128 -  lab_pin  IS MISSING !!!!
*  p129 -  lab_pin  IS MISSING !!!!
*  p130 -  lab_pin  IS MISSING !!!!
*  p131 -  lab_pin  IS MISSING !!!!
*  p132 -  lab_pin  IS MISSING !!!!
*  p133 -  lab_pin  IS MISSING !!!!
*  p134 -  lab_pin  IS MISSING !!!!
*  p135 -  lab_pin  IS MISSING !!!!
*  p136 -  lab_pin  IS MISSING !!!!
*  p137 -  lab_pin  IS MISSING !!!!
*  p138 -  lab_pin  IS MISSING !!!!
*  p139 -  lab_pin  IS MISSING !!!!
*  p140 -  lab_pin  IS MISSING !!!!
*  p141 -  lab_pin  IS MISSING !!!!
*  p142 -  lab_pin  IS MISSING !!!!
*  p143 -  lab_pin  IS MISSING !!!!
*  p144 -  lab_pin  IS MISSING !!!!
*  p145 -  lab_pin  IS MISSING !!!!
*  p146 -  lab_pin  IS MISSING !!!!
*  p147 -  lab_pin  IS MISSING !!!!
*  p148 -  lab_pin  IS MISSING !!!!
*  p149 -  lab_pin  IS MISSING !!!!
*  p150 -  lab_pin  IS MISSING !!!!
*  p151 -  lab_pin  IS MISSING !!!!
*  p152 -  lab_pin  IS MISSING !!!!
*  p153 -  lab_pin  IS MISSING !!!!
*  p154 -  lab_pin  IS MISSING !!!!
*  p155 -  lab_pin  IS MISSING !!!!
*  p156 -  lab_pin  IS MISSING !!!!
*  p157 -  lab_pin  IS MISSING !!!!
*  p158 -  lab_pin  IS MISSING !!!!
*  p159 -  lab_pin  IS MISSING !!!!
*  p160 -  lab_pin  IS MISSING !!!!
*  p161 -  lab_pin  IS MISSING !!!!
*  p162 -  lab_pin  IS MISSING !!!!
*  p163 -  lab_pin  IS MISSING !!!!
*  p164 -  lab_pin  IS MISSING !!!!
*  p165 -  lab_pin  IS MISSING !!!!
*  p166 -  lab_pin  IS MISSING !!!!
*  p167 -  lab_pin  IS MISSING !!!!
*  p168 -  lab_pin  IS MISSING !!!!
*  p169 -  lab_pin  IS MISSING !!!!
*  p170 -  lab_pin  IS MISSING !!!!
*  p171 -  lab_pin  IS MISSING !!!!
*  p172 -  lab_pin  IS MISSING !!!!
*  p173 -  lab_pin  IS MISSING !!!!
*  p174 -  lab_pin  IS MISSING !!!!
*  p175 -  lab_pin  IS MISSING !!!!
*  p176 -  lab_pin  IS MISSING !!!!
*  p177 -  lab_pin  IS MISSING !!!!
*  p178 -  lab_pin  IS MISSING !!!!
*  p179 -  lab_pin  IS MISSING !!!!
*  p180 -  lab_pin  IS MISSING !!!!
*  p181 -  lab_pin  IS MISSING !!!!
*  p182 -  lab_pin  IS MISSING !!!!
*  p183 -  lab_pin  IS MISSING !!!!
*  p184 -  lab_pin  IS MISSING !!!!
*  p185 -  lab_pin  IS MISSING !!!!
*  p186 -  lab_pin  IS MISSING !!!!
*  p187 -  lab_pin  IS MISSING !!!!
*  p188 -  lab_pin  IS MISSING !!!!
*  p189 -  lab_pin  IS MISSING !!!!
*  p190 -  lab_pin  IS MISSING !!!!
*  p191 -  lab_pin  IS MISSING !!!!
*  p192 -  lab_pin  IS MISSING !!!!
*  p193 -  lab_pin  IS MISSING !!!!
*  p194 -  lab_pin  IS MISSING !!!!
*  p195 -  lab_pin  IS MISSING !!!!
*  p196 -  lab_pin  IS MISSING !!!!
*  p197 -  lab_pin  IS MISSING !!!!
*  p198 -  lab_pin  IS MISSING !!!!
*  p199 -  lab_pin  IS MISSING !!!!
*  p200 -  lab_pin  IS MISSING !!!!
*  p201 -  lab_pin  IS MISSING !!!!
*  p202 -  lab_pin  IS MISSING !!!!
*  p203 -  lab_pin  IS MISSING !!!!
*  p204 -  lab_pin  IS MISSING !!!!
*  p205 -  lab_pin  IS MISSING !!!!
*  p206 -  lab_pin  IS MISSING !!!!
*  p207 -  lab_pin  IS MISSING !!!!
*  p208 -  lab_pin  IS MISSING !!!!
*  p209 -  lab_pin  IS MISSING !!!!
*  p210 -  lab_pin  IS MISSING !!!!
*  p211 -  lab_pin  IS MISSING !!!!
*  p212 -  lab_pin  IS MISSING !!!!
*  p213 -  lab_pin  IS MISSING !!!!
*  p214 -  lab_pin  IS MISSING !!!!
*  p215 -  lab_pin  IS MISSING !!!!
*  p216 -  lab_pin  IS MISSING !!!!
*  p217 -  lab_pin  IS MISSING !!!!
*  p218 -  lab_pin  IS MISSING !!!!
*  p219 -  lab_pin  IS MISSING !!!!
*  p220 -  lab_pin  IS MISSING !!!!
*  p221 -  lab_pin  IS MISSING !!!!
*  p222 -  lab_pin  IS MISSING !!!!
*  p223 -  lab_pin  IS MISSING !!!!
*  p224 -  lab_pin  IS MISSING !!!!
*  p225 -  lab_pin  IS MISSING !!!!
*  p226 -  lab_pin  IS MISSING !!!!
*  p227 -  lab_pin  IS MISSING !!!!
*  p228 -  lab_pin  IS MISSING !!!!
*  p229 -  lab_pin  IS MISSING !!!!
*  p230 -  lab_pin  IS MISSING !!!!
*  p231 -  lab_pin  IS MISSING !!!!
*  p232 -  lab_pin  IS MISSING !!!!
*  p233 -  lab_pin  IS MISSING !!!!
*  p234 -  lab_pin  IS MISSING !!!!
*  p235 -  lab_pin  IS MISSING !!!!
*  p236 -  lab_pin  IS MISSING !!!!
*  p237 -  lab_pin  IS MISSING !!!!
*  p238 -  lab_pin  IS MISSING !!!!
*  p239 -  lab_pin  IS MISSING !!!!
*  p240 -  lab_pin  IS MISSING !!!!
*  p241 -  lab_pin  IS MISSING !!!!
*  p242 -  lab_pin  IS MISSING !!!!
*  p243 -  lab_pin  IS MISSING !!!!
*  p244 -  lab_pin  IS MISSING !!!!
*  p245 -  lab_pin  IS MISSING !!!!
*  p246 -  lab_pin  IS MISSING !!!!
*  p247 -  lab_pin  IS MISSING !!!!
*  p248 -  lab_pin  IS MISSING !!!!
*  p249 -  lab_pin  IS MISSING !!!!
*  p250 -  lab_pin  IS MISSING !!!!
*  p251 -  lab_pin  IS MISSING !!!!
*  p252 -  lab_pin  IS MISSING !!!!
*  p253 -  lab_pin  IS MISSING !!!!
*  p254 -  lab_pin  IS MISSING !!!!
*  p255 -  lab_pin  IS MISSING !!!!
*  p256 -  lab_pin  IS MISSING !!!!
*  p257 -  lab_pin  IS MISSING !!!!
*  p258 -  lab_pin  IS MISSING !!!!
*  p259 -  lab_pin  IS MISSING !!!!
*  p260 -  lab_pin  IS MISSING !!!!
*  p261 -  lab_pin  IS MISSING !!!!
*  p262 -  lab_pin  IS MISSING !!!!
*  p263 -  lab_pin  IS MISSING !!!!
*  p264 -  lab_pin  IS MISSING !!!!
*  p265 -  lab_pin  IS MISSING !!!!
*  p266 -  lab_pin  IS MISSING !!!!
*  p267 -  lab_pin  IS MISSING !!!!
*  p268 -  lab_pin  IS MISSING !!!!
*  p269 -  lab_pin  IS MISSING !!!!
*  p270 -  lab_pin  IS MISSING !!!!
*  p271 -  lab_pin  IS MISSING !!!!
*  p272 -  lab_pin  IS MISSING !!!!
*  p273 -  lab_pin  IS MISSING !!!!
*  p274 -  lab_pin  IS MISSING !!!!
*  p275 -  lab_pin  IS MISSING !!!!
*  p276 -  lab_pin  IS MISSING !!!!
*  p277 -  lab_pin  IS MISSING !!!!
*  p278 -  lab_pin  IS MISSING !!!!
*  p279 -  lab_pin  IS MISSING !!!!
*  p280 -  lab_pin  IS MISSING !!!!
*  p281 -  lab_pin  IS MISSING !!!!
*  p282 -  lab_pin  IS MISSING !!!!
*  p283 -  lab_pin  IS MISSING !!!!
*  p284 -  lab_pin  IS MISSING !!!!
*  p285 -  lab_pin  IS MISSING !!!!
*  p286 -  lab_pin  IS MISSING !!!!
*  p287 -  lab_pin  IS MISSING !!!!
*  p288 -  lab_pin  IS MISSING !!!!
*  p289 -  lab_pin  IS MISSING !!!!
*  p290 -  lab_pin  IS MISSING !!!!
*  p291 -  lab_pin  IS MISSING !!!!
*  p292 -  lab_pin  IS MISSING !!!!
*  p293 -  lab_pin  IS MISSING !!!!
*  p294 -  lab_pin  IS MISSING !!!!
*  p295 -  lab_pin  IS MISSING !!!!
*  p296 -  lab_pin  IS MISSING !!!!
*  p297 -  lab_pin  IS MISSING !!!!
*  p298 -  lab_pin  IS MISSING !!!!
*  p299 -  lab_pin  IS MISSING !!!!
*  p300 -  lab_pin  IS MISSING !!!!
*  p301 -  lab_pin  IS MISSING !!!!
*  p302 -  lab_pin  IS MISSING !!!!
*  p303 -  lab_pin  IS MISSING !!!!
*  p304 -  lab_pin  IS MISSING !!!!
*  p305 -  lab_pin  IS MISSING !!!!
*  p306 -  lab_pin  IS MISSING !!!!
*  p307 -  lab_pin  IS MISSING !!!!
*  p308 -  lab_pin  IS MISSING !!!!
*  p309 -  lab_pin  IS MISSING !!!!
*  p310 -  lab_pin  IS MISSING !!!!
*  p311 -  lab_pin  IS MISSING !!!!
*  p312 -  lab_pin  IS MISSING !!!!
*  p313 -  lab_pin  IS MISSING !!!!
*  p314 -  lab_pin  IS MISSING !!!!
*  p315 -  lab_pin  IS MISSING !!!!
*  p316 -  lab_pin  IS MISSING !!!!
*  p317 -  lab_pin  IS MISSING !!!!
*  p318 -  lab_pin  IS MISSING !!!!
*  p319 -  lab_pin  IS MISSING !!!!
*  p320 -  lab_pin  IS MISSING !!!!
*  p321 -  lab_pin  IS MISSING !!!!
*  p322 -  lab_pin  IS MISSING !!!!
*  p323 -  lab_pin  IS MISSING !!!!
*  p324 -  lab_pin  IS MISSING !!!!
*  p325 -  lab_pin  IS MISSING !!!!
*  p326 -  lab_pin  IS MISSING !!!!
*  p327 -  lab_pin  IS MISSING !!!!
*  p328 -  lab_pin  IS MISSING !!!!
*  p329 -  lab_pin  IS MISSING !!!!
*  p330 -  lab_pin  IS MISSING !!!!
*  p331 -  lab_pin  IS MISSING !!!!
*  p332 -  lab_pin  IS MISSING !!!!
*  p333 -  lab_pin  IS MISSING !!!!
*  p334 -  lab_pin  IS MISSING !!!!
*  p335 -  lab_pin  IS MISSING !!!!
*  p336 -  lab_pin  IS MISSING !!!!
*  p337 -  lab_pin  IS MISSING !!!!
*  p338 -  lab_pin  IS MISSING !!!!
*  p339 -  lab_pin  IS MISSING !!!!
*  p340 -  lab_pin  IS MISSING !!!!
*  p341 -  lab_pin  IS MISSING !!!!
*  p342 -  lab_pin  IS MISSING !!!!
*  p343 -  lab_pin  IS MISSING !!!!
*  p344 -  lab_pin  IS MISSING !!!!
*  p345 -  lab_pin  IS MISSING !!!!
.ends
