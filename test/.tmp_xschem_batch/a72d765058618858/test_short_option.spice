** sch_path: /nix/store/qriw4afhakn3sqg2al06kdyr745hx86w-xschem-3.4.7/share/doc/xschem/examples/test_short_option.sch
.subckt test_short_option NET_D NET_C NET_A
*.PININFO NET_D:I NET_C:I NET_A:I
* short x2 : NET_A <--> NET_A
* short x5 : #net1 <--> #net1
x3 NET_E net1 inv_ngspice RUP=2000 RDOWN=1000
x6 NET_B NET_A inv_ngspice RUP=2000 RDOWN=1000
x7 net1 net1 inv_ngspice RUP=2000 RDOWN=1000
x8 NET_A NET_A inv_ngspice RUP=2000 RDOWN=1000
x4 NET_E NET_E NET_B and_ngspice ROUT=1000
* short x1 : NET_E <--> NET_E
Vopt2 NET_C net1 0
.save i(vopt2)
Vopt1 NET_D net1 0
.save i(vopt1)
x10 net2 NET_B inv_ngspice RUP=2000 RDOWN=1000
x11 NET_F net2 inv_ngspice RUP=2000 RDOWN=1000
.ends

* expanding   symbol:  inv_ngspice.sym # of pins=2
** sym_path: /nix/store/qriw4afhakn3sqg2al06kdyr745hx86w-xschem-3.4.7/share/doc/xschem/ngspice/inv_ngspice.sym
** sch_path: /nix/store/qriw4afhakn3sqg2al06kdyr745hx86w-xschem-3.4.7/share/doc/xschem/ngspice/inv_ngspice.sch
.subckt inv_ngspice Y A  RUP=2000 RDOWN=1000
*.PININFO A:I Y:O
B1 X1 0 V = 'VCC/2*(1-tanh((V(A1)-VCC/2)*100))' m=1
C1 A1 0 8f m=1
C2 Y1 0 8f m=1
V1 Y Y1 0
.save i(v1)
V2 A1 A 0
.save i(v2)
B2 X1 Y1 I = 'v(X1,Y1) > 0 ? v(X1,Y1) / RUP : v(X1,Y1) / RDOWN' m=1
.ends

* expanding   symbol:  and_ngspice.sym # of pins=3
** sym_path: /nix/store/qriw4afhakn3sqg2al06kdyr745hx86w-xschem-3.4.7/share/doc/xschem/ngspice/and_ngspice.sym
** sch_path: /nix/store/qriw4afhakn3sqg2al06kdyr745hx86w-xschem-3.4.7/share/doc/xschem/ngspice/and_ngspice.sch
.subckt and_ngspice Y A B  ROUT=1000
*.PININFO A:I Y:O B:I
B1 net1 0 V = 'VCC/2*(1+tanh((min(V(A1),V(B1))-VCC/2)*100))' m=1
R1 Y1 net1 'ROUT' m=1
C1 A1 0 8f m=1
C2 B1 0 8f m=1
C3 Y1 0 8f m=1
V1 A1 A 0
V2 B1 B 0
V3 Y Y1 0
.ends
