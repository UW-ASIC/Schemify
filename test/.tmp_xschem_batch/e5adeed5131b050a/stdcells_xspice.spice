** sch_path: /home/omare/Documents/UWASIC/Schemify/test/examples/xschem_sky130/sky130_tests/stdcells_xspice.sch
.subckt stdcells_xspice QLATCH A X B Y CLK Q RESET_B XSCHEM VCC VSS

*  l1 -  title  IS MISSING !!!!
*  p1 -  ipin  IS MISSING !!!!
*  p2 -  ipin  IS MISSING !!!!
*  p3 -  ipin  IS MISSING !!!!
*  p4 -  ipin  IS MISSING !!!!
*  p1 -  opin  IS MISSING !!!!
*  p2 -  opin  IS MISSING !!!!
*  p3 -  opin  IS MISSING !!!!
*  p1 -  opin  IS MISSING !!!!
*  p1 -  opin  IS MISSING !!!!
*  p1 -  ipin  IS MISSING !!!!
*  p1 -  ipin  IS MISSING !!!!
*  XSPICE -  code_shown  IS MISSING !!!!
*  l2 -  noconn  IS MISSING !!!!
*  l3 -  noconn  IS MISSING !!!!
*  l4 -  noconn  IS MISSING !!!!
*  l5 -  noconn  IS MISSING !!!!
*  l6 -  noconn  IS MISSING !!!!
*  l7 -  noconn  IS MISSING !!!!
*  l8 -  noconn  IS MISSING !!!!
*  l9 -  noconn  IS MISSING !!!!
*  l10 -  noconn  IS MISSING !!!!
*  l11 -  noconn  IS MISSING !!!!
*  l12 -  noconn  IS MISSING !!!!
.ends
