** sch_path: /nix/store/qriw4afhakn3sqg2al06kdyr745hx86w-xschem-3.4.7/share/doc/xschem/examples/real_capa.sch
.subckt real_capa USC
*.PININFO USC:B
.ends
