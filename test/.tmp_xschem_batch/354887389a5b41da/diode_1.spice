** sch_path: /nix/store/qriw4afhakn3sqg2al06kdyr745hx86w-xschem-3.4.7/share/doc/xschem/examples/diode_1.sch
.subckt diode_1 p m
*.PININFO p:B m:B
G2 p m vcr pwl(1) p m 'VTH-0.1' ROFF 'VTH+0.1' RON
.ends
