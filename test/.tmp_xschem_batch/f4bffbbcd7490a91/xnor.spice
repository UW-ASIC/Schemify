** sch_path: /nix/store/qriw4afhakn3sqg2al06kdyr745hx86w-xschem-3.4.7/share/doc/xschem/examples/xnor.sch
.subckt xnor Z A B
*.PININFO B:I Z:O A:I
M1 net2 A GND GND nmos w=10u l=1u m=1
M2 net3 net1 GND GND nmos w=10u l=1u m=1
M3 Z A net3 GND nmos w=10u l=1u m=1
M4 Z B net3 GND nmos w=10u l=1u m=1
M5 net1 B net2 GND nmos w=10u l=1u m=1
M6 net1 A VDD VDD pmos w=10u l=1u m=1
M7 net1 B VDD VDD pmos w=10u l=1u m=1
M8 net4 A VDD VDD pmos w=10u l=1u m=1
M9 Z B net4 VDD pmos w=10u l=1u m=1
M10 Z net1 VDD VDD pmos w=10u l=1u m=1
.ends
.GLOBAL GND
.GLOBAL VDD
