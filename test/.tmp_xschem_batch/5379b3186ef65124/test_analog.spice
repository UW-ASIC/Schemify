** sch_path: /home/omare/Documents/UWASIC/Schemify/test/examples/xschem_sky130/sky130_tests/test_analog.sch
.subckt test_analog

*  l1 -  title  IS MISSING !!!!
*  x1 -  n_diffamp  IS MISSING !!!!
*  x2 -  n_diffamp  IS MISSING !!!!
*  l2 -  lab_pin  IS MISSING !!!!
*  l3 -  lab_pin  IS MISSING !!!!
*  l5 -  lab_pin  IS MISSING !!!!
*  l6 -  lab_pin  IS MISSING !!!!
*  l7 -  lab_pin  IS MISSING !!!!
*  V1 -  vsource  IS MISSING !!!!
*  l9 -  gnd  IS MISSING !!!!
*  l10 -  lab_pin  IS MISSING !!!!
*  V2 -  vsource  IS MISSING !!!!
*  l11 -  gnd  IS MISSING !!!!
*  l12 -  lab_pin  IS MISSING !!!!
*  V3 -  vsource  IS MISSING !!!!
*  l13 -  gnd  IS MISSING !!!!
*  l14 -  vdd  IS MISSING !!!!
*  l4 -  lab_pin  IS MISSING !!!!
*  V4 -  vsource  IS MISSING !!!!
*  l8 -  gnd  IS MISSING !!!!
*  l15 -  lab_pin  IS MISSING !!!!
*  V5 -  vsource  IS MISSING !!!!
*  l16 -  gnd  IS MISSING !!!!
*  l17 -  lab_pin  IS MISSING !!!!
*  h2 -  launcher  IS MISSING !!!!
*  R1 -  res_xhigh_po_0p35  IS MISSING !!!!
*  l18 -  gnd  IS MISSING !!!!
*  l19 -  gnd  IS MISSING !!!!
*  r7 -  ngspice_get_value  IS MISSING !!!!
*  R2 -  res_xhigh_po_0p35  IS MISSING !!!!
*  l20 -  gnd  IS MISSING !!!!
*  l21 -  gnd  IS MISSING !!!!
*  r9 -  ngspice_get_value  IS MISSING !!!!
*  r8 -  ngspice_get_expr  IS MISSING !!!!
*  h1 -  launcher  IS MISSING !!!!
*  COMMANDS -  simulator_commands  IS MISSING !!!!
*  h3 -  launcher  IS MISSING !!!!
?
.ends
