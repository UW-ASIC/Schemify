** sch_path: /home/omare/Documents/UWASIC/Schemify/test/examples/xschem_sky130/sky130_tests/test_vpp_cap.sch
.subckt test_vpp_cap

*  NGSPICE -  code_shown  IS MISSING !!!!
*  l1 -  title  IS MISSING !!!!
*  p4 -  lab_pin  IS MISSING !!!!
*  I1 -  isource  IS MISSING !!!!
*  p1 -  lab_pin  IS MISSING !!!!
*  p2 -  lab_pin  IS MISSING !!!!
*  R1 -  res  IS MISSING !!!!
*  p5 -  lab_pin  IS MISSING !!!!
*  p9 -  lab_pin  IS MISSING !!!!
*  I3 -  isource  IS MISSING !!!!
*  p11 -  lab_pin  IS MISSING !!!!
*  p12 -  lab_pin  IS MISSING !!!!
*  R3 -  res  IS MISSING !!!!
*  p13 -  lab_pin  IS MISSING !!!!
*  C2 -  capa  IS MISSING !!!!
*  V1 -  vsource  IS MISSING !!!!
*  p14 -  lab_pin  IS MISSING !!!!
*  p15 -  lab_pin  IS MISSING !!!!
*  p3 -  lab_pin  IS MISSING !!!!
*  C1 -  vpp_cap  IS MISSING !!!!
?
*  h5 -  launcher  IS MISSING !!!!
*  p6 -  lab_pin  IS MISSING !!!!
*  I2 -  isource  IS MISSING !!!!
*  p7 -  lab_pin  IS MISSING !!!!
*  p8 -  lab_pin  IS MISSING !!!!
*  R2 -  res  IS MISSING !!!!
*  p10 -  lab_pin  IS MISSING !!!!
*  p16 -  lab_pin  IS MISSING !!!!
*  C4 -  vpp_cap  IS MISSING !!!!
*  p17 -  lab_pin  IS MISSING !!!!
*  I4 -  isource  IS MISSING !!!!
*  p18 -  lab_pin  IS MISSING !!!!
*  p19 -  lab_pin  IS MISSING !!!!
*  R4 -  res  IS MISSING !!!!
*  p20 -  lab_pin  IS MISSING !!!!
*  C3 -  capa  IS MISSING !!!!
*  Vc1 -  ammeter  IS MISSING !!!!
*  Vc2 -  ammeter  IS MISSING !!!!
*  Vc3 -  ammeter  IS MISSING !!!!
*  Vc4 -  ammeter  IS MISSING !!!!
.ends
