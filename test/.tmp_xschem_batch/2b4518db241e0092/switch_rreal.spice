** sch_path: /nix/store/qriw4afhakn3sqg2al06kdyr745hx86w-xschem-3.4.7/share/doc/xschem/examples/switch_rreal.sch
.subckt switch_rreal ENAB B A
*.PININFO ENAB:I A:B B:B
.ends
