** sch_path: /home/omare/Documents/UWASIC/Schemify/test/examples/xschem_sky130/sky130_tests/optimize_delay.sch
.subckt optimize_delay

*  V1 -  vsource  IS MISSING !!!!
*  p9 -  lab_pin  IS MISSING !!!!
*  V2 -  vsource  IS MISSING !!!!
*  p1 -  lab_pin  IS MISSING !!!!
*  p2 -  lab_pin  IS MISSING !!!!
?
*  l2 -  title  IS MISSING !!!!
*  STIMULI -  code  IS MISSING !!!!
*  h5 -  launcher  IS MISSING !!!!
*  l3 -  noconn  IS MISSING !!!!
*  p32 -  lab_pin  IS MISSING !!!!
*  C1 -  parax_cap  IS MISSING !!!!
*  C2 -  parax_cap  IS MISSING !!!!
*  C3 -  parax_cap  IS MISSING !!!!
*  x4 -  not  IS MISSING !!!!
*  x1 -  not  IS MISSING !!!!
*  x2 -  not  IS MISSING !!!!
*  x3 -  not  IS MISSING !!!!
*  p3 -  lab_pin  IS MISSING !!!!
*  p4 -  lab_pin  IS MISSING !!!!
*  C4 -  capa  IS MISSING !!!!
*  p5 -  lab_pin  IS MISSING !!!!
*  h1 -  launcher  IS MISSING !!!!
.ends
