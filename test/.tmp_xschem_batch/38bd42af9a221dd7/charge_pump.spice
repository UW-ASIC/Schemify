** sch_path: /home/omare/Documents/UWASIC/Schemify/test/examples/xschem_sky130/sky130_tests/charge_pump.sch
.subckt charge_pump VCC HV A B C D

*  M1 -  nfet_g5v0d10v5  IS MISSING !!!!
*  M2 -  nfet_g5v0d10v5  IS MISSING !!!!
*  M3 -  nfet_g5v0d10v5  IS MISSING !!!!
*  M4 -  nfet_g5v0d10v5  IS MISSING !!!!
*  M5 -  nfet_g5v0d10v5  IS MISSING !!!!
*  M6 -  nfet_g5v0d10v5  IS MISSING !!!!
*  M7 -  nfet_g5v0d10v5  IS MISSING !!!!
*  C1 -  cap_mim_m3_1  IS MISSING !!!!
*  C2 -  cap_mim_m3_1  IS MISSING !!!!
*  C3 -  cap_mim_m3_1  IS MISSING !!!!
*  C4 -  cap_mim_m3_1  IS MISSING !!!!
*  C5 -  cap_mim_m3_1  IS MISSING !!!!
*  C6 -  cap_mim_m3_1  IS MISSING !!!!
*  p9 -  ipin  IS MISSING !!!!
*  p10 -  ipin  IS MISSING !!!!
*  p11 -  ipin  IS MISSING !!!!
*  p12 -  ipin  IS MISSING !!!!
*  l1 -  title  IS MISSING !!!!
*  p1 -  lab_wire  IS MISSING !!!!
*  p2 -  lab_wire  IS MISSING !!!!
*  p3 -  lab_pin  IS MISSING !!!!
*  p4 -  lab_pin  IS MISSING !!!!
*  p7 -  lab_pin  IS MISSING !!!!
*  p8 -  lab_pin  IS MISSING !!!!
*  p13 -  lab_pin  IS MISSING !!!!
*  p14 -  lab_pin  IS MISSING !!!!
*  p15 -  lab_pin  IS MISSING !!!!
*  p16 -  lab_wire  IS MISSING !!!!
*  p17 -  lab_wire  IS MISSING !!!!
*  p18 -  lab_wire  IS MISSING !!!!
*  p19 -  lab_wire  IS MISSING !!!!
*  p5 -  ipin  IS MISSING !!!!
*  M8 -  nfet_g5v0d10v5  IS MISSING !!!!
*  M9 -  nfet_g5v0d10v5  IS MISSING !!!!
*  M10 -  nfet_g5v0d10v5  IS MISSING !!!!
*  M11 -  nfet_g5v0d10v5  IS MISSING !!!!
*  p20 -  iopin  IS MISSING !!!!
*  M12 -  nfet_g5v0d10v5  IS MISSING !!!!
*  M13 -  nfet_g5v0d10v5  IS MISSING !!!!
*  M14 -  nfet_g5v0d10v5  IS MISSING !!!!
*  C7 -  cap_mim_m3_1  IS MISSING !!!!
*  C8 -  cap_mim_m3_1  IS MISSING !!!!
*  C9 -  cap_mim_m3_1  IS MISSING !!!!
*  C10 -  cap_mim_m3_1  IS MISSING !!!!
*  C11 -  cap_mim_m3_1  IS MISSING !!!!
*  C12 -  cap_mim_m3_1  IS MISSING !!!!
*  p21 -  lab_wire  IS MISSING !!!!
*  p22 -  lab_wire  IS MISSING !!!!
*  p23 -  lab_pin  IS MISSING !!!!
*  p24 -  lab_pin  IS MISSING !!!!
*  p25 -  lab_pin  IS MISSING !!!!
*  p26 -  lab_pin  IS MISSING !!!!
*  p27 -  lab_pin  IS MISSING !!!!
*  p28 -  lab_pin  IS MISSING !!!!
*  p29 -  lab_pin  IS MISSING !!!!
*  p30 -  lab_wire  IS MISSING !!!!
*  p31 -  lab_wire  IS MISSING !!!!
*  p32 -  lab_wire  IS MISSING !!!!
*  p33 -  lab_wire  IS MISSING !!!!
*  p34 -  lab_pin  IS MISSING !!!!
*  h2 -  launcher  IS MISSING !!!!
*  V1 -  ammeter  IS MISSING !!!!
*  V2 -  ammeter  IS MISSING !!!!
*  V3 -  ammeter  IS MISSING !!!!
*  V4 -  ammeter  IS MISSING !!!!
*  V5 -  ammeter  IS MISSING !!!!
*  V6 -  ammeter  IS MISSING !!!!
*  V7 -  ammeter  IS MISSING !!!!
*  V8 -  ammeter  IS MISSING !!!!
*  V9 -  ammeter  IS MISSING !!!!
*  V10 -  ammeter  IS MISSING !!!!
*  V11 -  ammeter  IS MISSING !!!!
*  V12 -  ammeter  IS MISSING !!!!
*  V13 -  ammeter  IS MISSING !!!!
*  V14 -  ammeter  IS MISSING !!!!
*  V15 -  ammeter  IS MISSING !!!!
*  V16 -  ammeter  IS MISSING !!!!
*  V17 -  ammeter  IS MISSING !!!!
*  V18 -  ammeter  IS MISSING !!!!
*  V19 -  ammeter  IS MISSING !!!!
*  V20 -  ammeter  IS MISSING !!!!
.ends
