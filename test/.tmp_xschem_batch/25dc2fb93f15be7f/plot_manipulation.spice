** sch_path: /nix/store/qriw4afhakn3sqg2al06kdyr745hx86w-xschem-3.4.7/share/doc/xschem/examples/plot_manipulation.sch
.subckt plot_manipulation

m1 S GN 0 0 cmosn w=5u l=2u m=1
m2 DIFFOUT G VCC VCC cmosp w=5u l=2u m=1
VVCC VCC 0 5
m3 GN GN 0 0 cmosn w=5u l=2u m=1
IBIAS 0 GN 100u
m4 G PLUS S 0 cmosn w=10u l=1u m=1
m5 DIFFOUT MINUS S 0 cmosn w=10u l=1u m=1
m6 G G VCC VCC cmosp w=5u l=2u m=1
VPLUS PLUS 0 2.5
V1 MINUS 0 2.5
CL DIFFOUT 0 2p m=1
**** begin user architecture code

** ngspice
.temp 30

** xyce
* .step temp list 30

** ngspice
* .save all

** models are generally not free: you must download
** SPICE models for active devices and put them  into the below
** referenced file in netlist/simulation directory.
.option savecurrents
.include "models_cmos_example.txt"
.control
save all
let vol = 0
let i = 1
set curplot = new         $ create a new plot
set myplot = $curplot     $ store the plot name
set curplotname = myplot
let s_vec = vector(61)
settype voltage s_vec
while vol <= 6
alter VVCC vol  $ change value of vcc source
op
let vol = vol + 0.1
set run = $&i  $ create a var from the vector
let i = i + 1
setplot $myplot
let s_vec[{$run}] = op{$run}.s  $ get operating point v(s) and store into vector
end
* current plot here is last set one, $myplot
compose vcc start=0 stop=6 step=0.1  $ build x-axis voltage
setscale vcc                         $ set as xaxis for myplot
settype voltage vcc
write plot_manipulation.raw
plot s_vec
quit 0
.endc

** ngspice
* .save all

** xyce, not needed if -r given om cmdline
* .print tran format=raw v(diffout) v(plus) v(minus)

**** end user architecture code
.ends
