** sch_path: /nix/store/qriw4afhakn3sqg2al06kdyr745hx86w-xschem-3.4.7/share/doc/xschem/examples/rlc.sch
.subckt rlc

C1 A B 50nF m=1
R1 A D 1k m=1
L1 B C 10mH m=1
V1 C 0 pulse 0 3 0 100n 100n 9.9u 20u
Vmeas D 0 0
.save i(vmeas)
**** begin user architecture code

.control

  save all
  tran 10n 800u uic
  let pow = i(v1) * v(a,b)
  meas tran cap_avg_pow avg pow from=600u to=800u
  write  rlc.raw
.endc

**** end user architecture code
.ends
