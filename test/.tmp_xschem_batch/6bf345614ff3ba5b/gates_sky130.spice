** sch_path: /home/omare/Documents/UWASIC/Schemify/test/examples/xschem_sky130/sky130_tests/gates_sky130.sch
.subckt gates_sky130

*  x1 -  a221o_1  IS MISSING !!!!
*  p1 -  lab_pin  IS MISSING !!!!
*  p2 -  lab_pin  IS MISSING !!!!
*  p3 -  lab_pin  IS MISSING !!!!
*  p4 -  lab_pin  IS MISSING !!!!
*  p5 -  lab_pin  IS MISSING !!!!
*  p6 -  lab_pin  IS MISSING !!!!
*  x2 -  a221oi_1  IS MISSING !!!!
*  p7 -  lab_pin  IS MISSING !!!!
*  p8 -  lab_pin  IS MISSING !!!!
*  p9 -  lab_pin  IS MISSING !!!!
*  p10 -  lab_pin  IS MISSING !!!!
*  p11 -  lab_pin  IS MISSING !!!!
*  x3 -  a22oi_1  IS MISSING !!!!
*  p13 -  lab_pin  IS MISSING !!!!
*  p14 -  lab_pin  IS MISSING !!!!
*  p15 -  lab_pin  IS MISSING !!!!
*  p16 -  lab_pin  IS MISSING !!!!
*  p17 -  lab_pin  IS MISSING !!!!
*  l1 -  title  IS MISSING !!!!
*  x4 -  a2111o_1  IS MISSING !!!!
*  p18 -  lab_pin  IS MISSING !!!!
*  p19 -  lab_pin  IS MISSING !!!!
*  p20 -  lab_pin  IS MISSING !!!!
*  p21 -  lab_pin  IS MISSING !!!!
*  p22 -  lab_pin  IS MISSING !!!!
*  p23 -  lab_pin  IS MISSING !!!!
*  x5 -  a2111oi_1  IS MISSING !!!!
*  p24 -  lab_pin  IS MISSING !!!!
*  p25 -  lab_pin  IS MISSING !!!!
*  p26 -  lab_pin  IS MISSING !!!!
*  p27 -  lab_pin  IS MISSING !!!!
*  p28 -  lab_pin  IS MISSING !!!!
*  x6 -  a211o_1  IS MISSING !!!!
*  p30 -  lab_pin  IS MISSING !!!!
*  p31 -  lab_pin  IS MISSING !!!!
*  p32 -  lab_pin  IS MISSING !!!!
*  p33 -  lab_pin  IS MISSING !!!!
*  p34 -  lab_pin  IS MISSING !!!!
*  x7 -  a211oi_1  IS MISSING !!!!
*  p35 -  lab_pin  IS MISSING !!!!
*  p36 -  lab_pin  IS MISSING !!!!
*  p37 -  lab_pin  IS MISSING !!!!
*  p38 -  lab_pin  IS MISSING !!!!
*  p39 -  lab_pin  IS MISSING !!!!
*  p29 -  lab_pin  IS MISSING !!!!
*  p12 -  lab_pin  IS MISSING !!!!
*  x8 -  a21o_1  IS MISSING !!!!
*  p40 -  lab_pin  IS MISSING !!!!
*  p41 -  lab_pin  IS MISSING !!!!
*  p42 -  lab_pin  IS MISSING !!!!
*  p43 -  lab_pin  IS MISSING !!!!
*  x9 -  a22o_1  IS MISSING !!!!
*  p44 -  lab_pin  IS MISSING !!!!
*  p45 -  lab_pin  IS MISSING !!!!
*  p46 -  lab_pin  IS MISSING !!!!
*  p47 -  lab_pin  IS MISSING !!!!
*  p48 -  lab_pin  IS MISSING !!!!
*  x10 -  a21bo_1  IS MISSING !!!!
*  p49 -  lab_pin  IS MISSING !!!!
*  p50 -  lab_pin  IS MISSING !!!!
*  p51 -  lab_pin  IS MISSING !!!!
*  p52 -  lab_pin  IS MISSING !!!!
*  x11 -  a21boi_1  IS MISSING !!!!
*  p53 -  lab_pin  IS MISSING !!!!
*  p54 -  lab_pin  IS MISSING !!!!
*  p55 -  lab_pin  IS MISSING !!!!
*  p56 -  lab_pin  IS MISSING !!!!
*  x12 -  a21oi_1  IS MISSING !!!!
*  p57 -  lab_pin  IS MISSING !!!!
*  p58 -  lab_pin  IS MISSING !!!!
*  p59 -  lab_pin  IS MISSING !!!!
*  p60 -  lab_pin  IS MISSING !!!!
*  x13 -  a222oi_1  IS MISSING !!!!
*  p61 -  lab_pin  IS MISSING !!!!
*  p62 -  lab_pin  IS MISSING !!!!
*  p63 -  lab_pin  IS MISSING !!!!
*  p64 -  lab_pin  IS MISSING !!!!
*  p65 -  lab_pin  IS MISSING !!!!
*  p66 -  lab_pin  IS MISSING !!!!
*  p67 -  lab_pin  IS MISSING !!!!
*  x14 -  a2bb2o_1  IS MISSING !!!!
*  p68 -  lab_pin  IS MISSING !!!!
*  p69 -  lab_pin  IS MISSING !!!!
*  p70 -  lab_pin  IS MISSING !!!!
*  p71 -  lab_pin  IS MISSING !!!!
*  p72 -  lab_pin  IS MISSING !!!!
*  x15 -  a2bb2oi_1  IS MISSING !!!!
*  p73 -  lab_pin  IS MISSING !!!!
*  p74 -  lab_pin  IS MISSING !!!!
*  p75 -  lab_pin  IS MISSING !!!!
*  p76 -  lab_pin  IS MISSING !!!!
*  p77 -  lab_pin  IS MISSING !!!!
*  x16 -  a311o_1  IS MISSING !!!!
*  p78 -  lab_pin  IS MISSING !!!!
*  p79 -  lab_pin  IS MISSING !!!!
*  p80 -  lab_pin  IS MISSING !!!!
*  p81 -  lab_pin  IS MISSING !!!!
*  p82 -  lab_pin  IS MISSING !!!!
*  p83 -  lab_pin  IS MISSING !!!!
*  x17 -  a311oi_1  IS MISSING !!!!
*  p84 -  lab_pin  IS MISSING !!!!
*  p85 -  lab_pin  IS MISSING !!!!
*  p86 -  lab_pin  IS MISSING !!!!
*  p87 -  lab_pin  IS MISSING !!!!
*  p88 -  lab_pin  IS MISSING !!!!
*  p89 -  lab_pin  IS MISSING !!!!
*  x18 -  a31o_1  IS MISSING !!!!
*  p90 -  lab_pin  IS MISSING !!!!
*  p91 -  lab_pin  IS MISSING !!!!
*  p92 -  lab_pin  IS MISSING !!!!
*  p93 -  lab_pin  IS MISSING !!!!
*  p94 -  lab_pin  IS MISSING !!!!
*  x19 -  a31oi_1  IS MISSING !!!!
*  p95 -  lab_pin  IS MISSING !!!!
*  p96 -  lab_pin  IS MISSING !!!!
*  p97 -  lab_pin  IS MISSING !!!!
*  p98 -  lab_pin  IS MISSING !!!!
*  p99 -  lab_pin  IS MISSING !!!!
*  x20 -  a32o_1  IS MISSING !!!!
*  p100 -  lab_pin  IS MISSING !!!!
*  p101 -  lab_pin  IS MISSING !!!!
*  p102 -  lab_pin  IS MISSING !!!!
*  p103 -  lab_pin  IS MISSING !!!!
*  p104 -  lab_pin  IS MISSING !!!!
*  p105 -  lab_pin  IS MISSING !!!!
*  x21 -  a32oi_1  IS MISSING !!!!
*  p106 -  lab_pin  IS MISSING !!!!
*  p107 -  lab_pin  IS MISSING !!!!
*  p108 -  lab_pin  IS MISSING !!!!
*  p109 -  lab_pin  IS MISSING !!!!
*  p110 -  lab_pin  IS MISSING !!!!
*  p111 -  lab_pin  IS MISSING !!!!
*  x22 -  a41o_1  IS MISSING !!!!
*  p112 -  lab_pin  IS MISSING !!!!
*  p113 -  lab_pin  IS MISSING !!!!
*  p114 -  lab_pin  IS MISSING !!!!
*  p115 -  lab_pin  IS MISSING !!!!
*  p116 -  lab_pin  IS MISSING !!!!
*  p117 -  lab_pin  IS MISSING !!!!
*  x23 -  a41oi_1  IS MISSING !!!!
*  p118 -  lab_pin  IS MISSING !!!!
*  p119 -  lab_pin  IS MISSING !!!!
*  p120 -  lab_pin  IS MISSING !!!!
*  p121 -  lab_pin  IS MISSING !!!!
*  p122 -  lab_pin  IS MISSING !!!!
*  p123 -  lab_pin  IS MISSING !!!!
*  x24 -  and2_1  IS MISSING !!!!
*  p124 -  lab_pin  IS MISSING !!!!
*  p125 -  lab_pin  IS MISSING !!!!
*  p126 -  lab_pin  IS MISSING !!!!
*  x25 -  and2b_1  IS MISSING !!!!
*  p127 -  lab_pin  IS MISSING !!!!
*  p128 -  lab_pin  IS MISSING !!!!
*  p129 -  lab_pin  IS MISSING !!!!
*  x26 -  and3_1  IS MISSING !!!!
*  p130 -  lab_pin  IS MISSING !!!!
*  p131 -  lab_pin  IS MISSING !!!!
*  p132 -  lab_pin  IS MISSING !!!!
*  p133 -  lab_pin  IS MISSING !!!!
*  x27 -  and3b_1  IS MISSING !!!!
*  p134 -  lab_pin  IS MISSING !!!!
*  p135 -  lab_pin  IS MISSING !!!!
*  p136 -  lab_pin  IS MISSING !!!!
*  p137 -  lab_pin  IS MISSING !!!!
*  x28 -  and4_1  IS MISSING !!!!
*  p138 -  lab_pin  IS MISSING !!!!
*  p139 -  lab_pin  IS MISSING !!!!
*  p140 -  lab_pin  IS MISSING !!!!
*  p141 -  lab_pin  IS MISSING !!!!
*  p142 -  lab_pin  IS MISSING !!!!
*  x29 -  and4b_1  IS MISSING !!!!
*  p143 -  lab_pin  IS MISSING !!!!
*  p144 -  lab_pin  IS MISSING !!!!
*  p145 -  lab_pin  IS MISSING !!!!
*  p146 -  lab_pin  IS MISSING !!!!
*  p147 -  lab_pin  IS MISSING !!!!
*  x30 -  and4bb_1  IS MISSING !!!!
*  p148 -  lab_pin  IS MISSING !!!!
*  p149 -  lab_pin  IS MISSING !!!!
*  p150 -  lab_pin  IS MISSING !!!!
*  p151 -  lab_pin  IS MISSING !!!!
*  p152 -  lab_pin  IS MISSING !!!!
*  x31 -  buf_1  IS MISSING !!!!
*  p153 -  lab_pin  IS MISSING !!!!
*  p154 -  lab_pin  IS MISSING !!!!
*  x32 -  clkbuf_1  IS MISSING !!!!
*  p155 -  lab_pin  IS MISSING !!!!
*  p156 -  lab_pin  IS MISSING !!!!
*  x33 -  clkinv_1  IS MISSING !!!!
*  p157 -  lab_pin  IS MISSING !!!!
*  p158 -  lab_pin  IS MISSING !!!!
*  x34 -  conb_1  IS MISSING !!!!
*  p159 -  lab_pin  IS MISSING !!!!
*  p160 -  lab_pin  IS MISSING !!!!
*  x35 -  clkdlybuf4s15_1  IS MISSING !!!!
*  p161 -  lab_pin  IS MISSING !!!!
*  p162 -  lab_pin  IS MISSING !!!!
*  x36 -  clkdlybuf4s18_1  IS MISSING !!!!
*  p163 -  lab_pin  IS MISSING !!!!
*  p164 -  lab_pin  IS MISSING !!!!
*  x37 -  clkdlybuf4s25_1  IS MISSING !!!!
*  p165 -  lab_pin  IS MISSING !!!!
*  p166 -  lab_pin  IS MISSING !!!!
*  x38 -  clkdlybuf4s50_1  IS MISSING !!!!
*  p167 -  lab_pin  IS MISSING !!!!
*  p168 -  lab_pin  IS MISSING !!!!
*  x39 -  nand2_1  IS MISSING !!!!
*  p169 -  lab_pin  IS MISSING !!!!
*  p170 -  lab_pin  IS MISSING !!!!
*  p171 -  lab_pin  IS MISSING !!!!
*  x40 -  nand2b_1  IS MISSING !!!!
*  p172 -  lab_pin  IS MISSING !!!!
*  p173 -  lab_pin  IS MISSING !!!!
*  p174 -  lab_pin  IS MISSING !!!!
*  x41 -  nand3_1  IS MISSING !!!!
*  p175 -  lab_pin  IS MISSING !!!!
*  p176 -  lab_pin  IS MISSING !!!!
*  p177 -  lab_pin  IS MISSING !!!!
*  p178 -  lab_pin  IS MISSING !!!!
*  x42 -  nand3b_1  IS MISSING !!!!
*  p180 -  lab_pin  IS MISSING !!!!
*  p181 -  lab_pin  IS MISSING !!!!
*  p182 -  lab_pin  IS MISSING !!!!
*  x43 -  nand4_1  IS MISSING !!!!
*  p183 -  lab_pin  IS MISSING !!!!
*  p184 -  lab_pin  IS MISSING !!!!
*  p185 -  lab_pin  IS MISSING !!!!
*  p186 -  lab_pin  IS MISSING !!!!
*  p187 -  lab_pin  IS MISSING !!!!
*  x44 -  nand4b_1  IS MISSING !!!!
*  p188 -  lab_pin  IS MISSING !!!!
*  p189 -  lab_pin  IS MISSING !!!!
*  p190 -  lab_pin  IS MISSING !!!!
*  p191 -  lab_pin  IS MISSING !!!!
*  p192 -  lab_pin  IS MISSING !!!!
*  x45 -  nand4bb_1  IS MISSING !!!!
*  p193 -  lab_pin  IS MISSING !!!!
*  p194 -  lab_pin  IS MISSING !!!!
*  p195 -  lab_pin  IS MISSING !!!!
*  p196 -  lab_pin  IS MISSING !!!!
*  p197 -  lab_pin  IS MISSING !!!!
*  x46 -  mux2_1  IS MISSING !!!!
*  p198 -  lab_pin  IS MISSING !!!!
*  p199 -  lab_pin  IS MISSING !!!!
*  p200 -  lab_pin  IS MISSING !!!!
*  p201 -  lab_pin  IS MISSING !!!!
*  x47 -  mux2i_1  IS MISSING !!!!
*  p202 -  lab_pin  IS MISSING !!!!
*  p203 -  lab_pin  IS MISSING !!!!
*  p204 -  lab_pin  IS MISSING !!!!
*  p205 -  lab_pin  IS MISSING !!!!
*  x48 -  maj3_1  IS MISSING !!!!
*  p206 -  lab_pin  IS MISSING !!!!
*  p207 -  lab_pin  IS MISSING !!!!
*  p208 -  lab_pin  IS MISSING !!!!
*  p209 -  lab_pin  IS MISSING !!!!
*  x49 -  mux4_1  IS MISSING !!!!
*  p210 -  lab_pin  IS MISSING !!!!
*  p211 -  lab_pin  IS MISSING !!!!
*  p212 -  lab_pin  IS MISSING !!!!
*  p213 -  lab_pin  IS MISSING !!!!
*  p214 -  lab_pin  IS MISSING !!!!
*  p215 -  lab_pin  IS MISSING !!!!
*  p216 -  lab_pin  IS MISSING !!!!
*  x50 -  inv_1  IS MISSING !!!!
*  p217 -  lab_pin  IS MISSING !!!!
*  p218 -  lab_pin  IS MISSING !!!!
*  x51 -  fa_1  IS MISSING !!!!
*  p219 -  lab_pin  IS MISSING !!!!
*  p220 -  lab_pin  IS MISSING !!!!
*  p221 -  lab_pin  IS MISSING !!!!
*  p222 -  lab_pin  IS MISSING !!!!
*  p223 -  lab_pin  IS MISSING !!!!
*  x52 -  fah_1  IS MISSING !!!!
*  p224 -  lab_pin  IS MISSING !!!!
*  p225 -  lab_pin  IS MISSING !!!!
*  p226 -  lab_pin  IS MISSING !!!!
*  p227 -  lab_pin  IS MISSING !!!!
*  p228 -  lab_pin  IS MISSING !!!!
*  x53 -  dlygate4sd1_1  IS MISSING !!!!
*  x54 -  dlygate4sd2_1  IS MISSING !!!!
*  x55 -  dlygate4sd3_1  IS MISSING !!!!
*  p229 -  lab_pin  IS MISSING !!!!
*  p230 -  lab_pin  IS MISSING !!!!
*  p231 -  lab_pin  IS MISSING !!!!
*  p232 -  lab_pin  IS MISSING !!!!
*  p233 -  lab_pin  IS MISSING !!!!
*  p234 -  lab_pin  IS MISSING !!!!
*  x57 -  dlymetal6s2s_1  IS MISSING !!!!
*  x58 -  dlymetal6s4s_1  IS MISSING !!!!
*  x59 -  dlymetal6s6s_1  IS MISSING !!!!
*  p237 -  lab_pin  IS MISSING !!!!
*  p238 -  lab_pin  IS MISSING !!!!
*  p239 -  lab_pin  IS MISSING !!!!
*  p240 -  lab_pin  IS MISSING !!!!
*  p241 -  lab_pin  IS MISSING !!!!
*  p242 -  lab_pin  IS MISSING !!!!
*  x60 -  ebufn_1  IS MISSING !!!!
*  p243 -  lab_pin  IS MISSING !!!!
*  p244 -  lab_pin  IS MISSING !!!!
*  p245 -  lab_pin  IS MISSING !!!!
*  x61 -  einvn_1  IS MISSING !!!!
*  p246 -  lab_pin  IS MISSING !!!!
*  p247 -  lab_pin  IS MISSING !!!!
*  p248 -  lab_pin  IS MISSING !!!!
*  x62 -  ha_1  IS MISSING !!!!
*  p249 -  lab_pin  IS MISSING !!!!
*  p250 -  lab_pin  IS MISSING !!!!
*  p251 -  lab_pin  IS MISSING !!!!
*  p252 -  lab_pin  IS MISSING !!!!
*  x63 -  einvp_1  IS MISSING !!!!
*  p253 -  lab_pin  IS MISSING !!!!
*  p254 -  lab_pin  IS MISSING !!!!
*  p255 -  lab_pin  IS MISSING !!!!
*  x64 -  fahcin_1  IS MISSING !!!!
*  p256 -  lab_pin  IS MISSING !!!!
*  p257 -  lab_pin  IS MISSING !!!!
*  p258 -  lab_pin  IS MISSING !!!!
*  p259 -  lab_pin  IS MISSING !!!!
*  p260 -  lab_pin  IS MISSING !!!!
*  x65 -  fahcon_1  IS MISSING !!!!
*  p261 -  lab_pin  IS MISSING !!!!
*  p262 -  lab_pin  IS MISSING !!!!
*  p263 -  lab_pin  IS MISSING !!!!
*  p264 -  lab_pin  IS MISSING !!!!
*  p265 -  lab_pin  IS MISSING !!!!
*  x66 -  nor2_1  IS MISSING !!!!
*  p266 -  lab_pin  IS MISSING !!!!
*  p267 -  lab_pin  IS MISSING !!!!
*  p268 -  lab_pin  IS MISSING !!!!
*  x67 -  nor2b_1  IS MISSING !!!!
*  p269 -  lab_pin  IS MISSING !!!!
*  p270 -  lab_pin  IS MISSING !!!!
*  p271 -  lab_pin  IS MISSING !!!!
*  x68 -  nor3_1  IS MISSING !!!!
*  p272 -  lab_pin  IS MISSING !!!!
*  p273 -  lab_pin  IS MISSING !!!!
*  p274 -  lab_pin  IS MISSING !!!!
*  p275 -  lab_pin  IS MISSING !!!!
*  x69 -  nor3b_1  IS MISSING !!!!
*  p276 -  lab_pin  IS MISSING !!!!
*  p277 -  lab_pin  IS MISSING !!!!
*  p278 -  lab_pin  IS MISSING !!!!
*  p279 -  lab_pin  IS MISSING !!!!
*  x70 -  nor4_1  IS MISSING !!!!
*  p280 -  lab_pin  IS MISSING !!!!
*  p281 -  lab_pin  IS MISSING !!!!
*  p282 -  lab_pin  IS MISSING !!!!
*  p283 -  lab_pin  IS MISSING !!!!
*  p284 -  lab_pin  IS MISSING !!!!
*  x71 -  nor4b_1  IS MISSING !!!!
*  p285 -  lab_pin  IS MISSING !!!!
*  p286 -  lab_pin  IS MISSING !!!!
*  p287 -  lab_pin  IS MISSING !!!!
*  p288 -  lab_pin  IS MISSING !!!!
*  p289 -  lab_pin  IS MISSING !!!!
*  x72 -  nor4bb_1  IS MISSING !!!!
*  p290 -  lab_pin  IS MISSING !!!!
*  p291 -  lab_pin  IS MISSING !!!!
*  p292 -  lab_pin  IS MISSING !!!!
*  p293 -  lab_pin  IS MISSING !!!!
*  p294 -  lab_pin  IS MISSING !!!!
*  x73 -  o21a_1  IS MISSING !!!!
*  p295 -  lab_pin  IS MISSING !!!!
*  p296 -  lab_pin  IS MISSING !!!!
*  p297 -  lab_pin  IS MISSING !!!!
*  p298 -  lab_pin  IS MISSING !!!!
*  x74 -  o21ai_1  IS MISSING !!!!
*  p299 -  lab_pin  IS MISSING !!!!
*  p300 -  lab_pin  IS MISSING !!!!
*  p301 -  lab_pin  IS MISSING !!!!
*  p302 -  lab_pin  IS MISSING !!!!
*  x75 -  o22a_1  IS MISSING !!!!
*  p303 -  lab_pin  IS MISSING !!!!
*  p304 -  lab_pin  IS MISSING !!!!
*  p305 -  lab_pin  IS MISSING !!!!
*  p306 -  lab_pin  IS MISSING !!!!
*  p307 -  lab_pin  IS MISSING !!!!
*  x76 -  o22ai_1  IS MISSING !!!!
*  p308 -  lab_pin  IS MISSING !!!!
*  p309 -  lab_pin  IS MISSING !!!!
*  p310 -  lab_pin  IS MISSING !!!!
*  p311 -  lab_pin  IS MISSING !!!!
*  p312 -  lab_pin  IS MISSING !!!!
*  x77 -  o211a_1  IS MISSING !!!!
*  p313 -  lab_pin  IS MISSING !!!!
*  p314 -  lab_pin  IS MISSING !!!!
*  p315 -  lab_pin  IS MISSING !!!!
*  p316 -  lab_pin  IS MISSING !!!!
*  p317 -  lab_pin  IS MISSING !!!!
*  x78 -  o211ai_1  IS MISSING !!!!
*  p318 -  lab_pin  IS MISSING !!!!
*  p319 -  lab_pin  IS MISSING !!!!
*  p320 -  lab_pin  IS MISSING !!!!
*  p321 -  lab_pin  IS MISSING !!!!
*  p322 -  lab_pin  IS MISSING !!!!
*  x79 -  o21ba_1  IS MISSING !!!!
*  p323 -  lab_pin  IS MISSING !!!!
*  p324 -  lab_pin  IS MISSING !!!!
*  p325 -  lab_pin  IS MISSING !!!!
*  p326 -  lab_pin  IS MISSING !!!!
*  x80 -  o21bai_1  IS MISSING !!!!
*  p327 -  lab_pin  IS MISSING !!!!
*  p328 -  lab_pin  IS MISSING !!!!
*  p329 -  lab_pin  IS MISSING !!!!
*  p330 -  lab_pin  IS MISSING !!!!
*  x81 -  o221a_1  IS MISSING !!!!
*  p331 -  lab_pin  IS MISSING !!!!
*  p332 -  lab_pin  IS MISSING !!!!
*  p333 -  lab_pin  IS MISSING !!!!
*  p334 -  lab_pin  IS MISSING !!!!
*  p335 -  lab_pin  IS MISSING !!!!
*  p336 -  lab_pin  IS MISSING !!!!
*  x82 -  o221ai_1  IS MISSING !!!!
*  p337 -  lab_pin  IS MISSING !!!!
*  p338 -  lab_pin  IS MISSING !!!!
*  p339 -  lab_pin  IS MISSING !!!!
*  p340 -  lab_pin  IS MISSING !!!!
*  p341 -  lab_pin  IS MISSING !!!!
*  p342 -  lab_pin  IS MISSING !!!!
*  x83 -  o31a_1  IS MISSING !!!!
*  p343 -  lab_pin  IS MISSING !!!!
*  p344 -  lab_pin  IS MISSING !!!!
*  p345 -  lab_pin  IS MISSING !!!!
*  p346 -  lab_pin  IS MISSING !!!!
*  p347 -  lab_pin  IS MISSING !!!!
*  x84 -  o31ai_1  IS MISSING !!!!
*  p348 -  lab_pin  IS MISSING !!!!
*  p349 -  lab_pin  IS MISSING !!!!
*  p350 -  lab_pin  IS MISSING !!!!
*  p351 -  lab_pin  IS MISSING !!!!
*  p352 -  lab_pin  IS MISSING !!!!
*  x85 -  o311a_1  IS MISSING !!!!
*  p353 -  lab_pin  IS MISSING !!!!
*  p354 -  lab_pin  IS MISSING !!!!
*  p355 -  lab_pin  IS MISSING !!!!
*  p356 -  lab_pin  IS MISSING !!!!
*  p357 -  lab_pin  IS MISSING !!!!
*  p358 -  lab_pin  IS MISSING !!!!
*  x86 -  o311ai_1  IS MISSING !!!!
*  p359 -  lab_pin  IS MISSING !!!!
*  p360 -  lab_pin  IS MISSING !!!!
*  p361 -  lab_pin  IS MISSING !!!!
*  p362 -  lab_pin  IS MISSING !!!!
*  p363 -  lab_pin  IS MISSING !!!!
*  p364 -  lab_pin  IS MISSING !!!!
*  x87 -  o2111a_1  IS MISSING !!!!
*  p367 -  lab_pin  IS MISSING !!!!
*  p368 -  lab_pin  IS MISSING !!!!
*  p369 -  lab_pin  IS MISSING !!!!
*  p370 -  lab_pin  IS MISSING !!!!
*  p365 -  lab_pin  IS MISSING !!!!
*  p366 -  lab_pin  IS MISSING !!!!
*  x88 -  o2111ai_1  IS MISSING !!!!
*  p371 -  lab_pin  IS MISSING !!!!
*  p372 -  lab_pin  IS MISSING !!!!
*  p373 -  lab_pin  IS MISSING !!!!
*  p374 -  lab_pin  IS MISSING !!!!
*  p375 -  lab_pin  IS MISSING !!!!
*  p376 -  lab_pin  IS MISSING !!!!
*  x89 -  o2bb2a_1  IS MISSING !!!!
*  p377 -  lab_pin  IS MISSING !!!!
*  p378 -  lab_pin  IS MISSING !!!!
*  p379 -  lab_pin  IS MISSING !!!!
*  p380 -  lab_pin  IS MISSING !!!!
*  p381 -  lab_pin  IS MISSING !!!!
*  x90 -  o2bb2ai_1  IS MISSING !!!!
*  p382 -  lab_pin  IS MISSING !!!!
*  p383 -  lab_pin  IS MISSING !!!!
*  p384 -  lab_pin  IS MISSING !!!!
*  p385 -  lab_pin  IS MISSING !!!!
*  p386 -  lab_pin  IS MISSING !!!!
*  x91 -  o32a_1  IS MISSING !!!!
*  p387 -  lab_pin  IS MISSING !!!!
*  p388 -  lab_pin  IS MISSING !!!!
*  p389 -  lab_pin  IS MISSING !!!!
*  p390 -  lab_pin  IS MISSING !!!!
*  p391 -  lab_pin  IS MISSING !!!!
*  p392 -  lab_pin  IS MISSING !!!!
*  x92 -  o32ai_1  IS MISSING !!!!
*  p393 -  lab_pin  IS MISSING !!!!
*  p394 -  lab_pin  IS MISSING !!!!
*  p395 -  lab_pin  IS MISSING !!!!
*  p396 -  lab_pin  IS MISSING !!!!
*  p397 -  lab_pin  IS MISSING !!!!
*  p398 -  lab_pin  IS MISSING !!!!
*  x93 -  o41a_1  IS MISSING !!!!
*  p399 -  lab_pin  IS MISSING !!!!
*  p400 -  lab_pin  IS MISSING !!!!
*  p401 -  lab_pin  IS MISSING !!!!
*  p402 -  lab_pin  IS MISSING !!!!
*  p403 -  lab_pin  IS MISSING !!!!
*  p404 -  lab_pin  IS MISSING !!!!
*  x94 -  o41ai_1  IS MISSING !!!!
*  p405 -  lab_pin  IS MISSING !!!!
*  p406 -  lab_pin  IS MISSING !!!!
*  p407 -  lab_pin  IS MISSING !!!!
*  p408 -  lab_pin  IS MISSING !!!!
*  p409 -  lab_pin  IS MISSING !!!!
*  p410 -  lab_pin  IS MISSING !!!!
*  x95 -  or2_1  IS MISSING !!!!
*  p411 -  lab_pin  IS MISSING !!!!
*  p412 -  lab_pin  IS MISSING !!!!
*  p413 -  lab_pin  IS MISSING !!!!
*  x96 -  or2b_1  IS MISSING !!!!
*  p414 -  lab_pin  IS MISSING !!!!
*  p415 -  lab_pin  IS MISSING !!!!
*  p416 -  lab_pin  IS MISSING !!!!
*  x97 -  or3_1  IS MISSING !!!!
*  p417 -  lab_pin  IS MISSING !!!!
*  p418 -  lab_pin  IS MISSING !!!!
*  p419 -  lab_pin  IS MISSING !!!!
*  p420 -  lab_pin  IS MISSING !!!!
*  x98 -  or3b_1  IS MISSING !!!!
*  p421 -  lab_pin  IS MISSING !!!!
*  p422 -  lab_pin  IS MISSING !!!!
*  p423 -  lab_pin  IS MISSING !!!!
*  p424 -  lab_pin  IS MISSING !!!!
*  x99 -  or4_1  IS MISSING !!!!
*  p425 -  lab_pin  IS MISSING !!!!
*  p426 -  lab_pin  IS MISSING !!!!
*  p427 -  lab_pin  IS MISSING !!!!
*  p428 -  lab_pin  IS MISSING !!!!
*  p429 -  lab_pin  IS MISSING !!!!
*  x100 -  or4b_1  IS MISSING !!!!
*  p430 -  lab_pin  IS MISSING !!!!
*  p431 -  lab_pin  IS MISSING !!!!
*  p432 -  lab_pin  IS MISSING !!!!
*  p433 -  lab_pin  IS MISSING !!!!
*  p434 -  lab_pin  IS MISSING !!!!
*  x101 -  or4bb_1  IS MISSING !!!!
*  p435 -  lab_pin  IS MISSING !!!!
*  p436 -  lab_pin  IS MISSING !!!!
*  p437 -  lab_pin  IS MISSING !!!!
*  p438 -  lab_pin  IS MISSING !!!!
*  p439 -  lab_pin  IS MISSING !!!!
*  x102 -  xnor2_1  IS MISSING !!!!
*  p440 -  lab_pin  IS MISSING !!!!
*  p441 -  lab_pin  IS MISSING !!!!
*  p442 -  lab_pin  IS MISSING !!!!
*  x103 -  xnor3_1  IS MISSING !!!!
*  p443 -  lab_pin  IS MISSING !!!!
*  p444 -  lab_pin  IS MISSING !!!!
*  p445 -  lab_pin  IS MISSING !!!!
*  p446 -  lab_pin  IS MISSING !!!!
*  x104 -  xor2_1  IS MISSING !!!!
*  p447 -  lab_pin  IS MISSING !!!!
*  p448 -  lab_pin  IS MISSING !!!!
*  p449 -  lab_pin  IS MISSING !!!!
*  x105 -  xor3_1  IS MISSING !!!!
*  p450 -  lab_pin  IS MISSING !!!!
*  p451 -  lab_pin  IS MISSING !!!!
*  p452 -  lab_pin  IS MISSING !!!!
*  p453 -  lab_pin  IS MISSING !!!!
*  x106 -  sdfbbn_1  IS MISSING !!!!
*  x107 -  sdfbbp_1  IS MISSING !!!!
*  x108 -  sdfrbp_1  IS MISSING !!!!
*  x109 -  sdfrtn_1  IS MISSING !!!!
*  x110 -  sdfrtp_1  IS MISSING !!!!
*  x111 -  sdfsbp_1  IS MISSING !!!!
*  x112 -  sdfstp_1  IS MISSING !!!!
*  x113 -  sdfxbp_1  IS MISSING !!!!
*  x114 -  sdlclkp_1  IS MISSING !!!!
*  x115 -  sedfxbp_1  IS MISSING !!!!
*  x116 -  sedfxtp_1  IS MISSING !!!!
*  x117 -  sdfxtp_1  IS MISSING !!!!
*  x118 -  dfbbn_1  IS MISSING !!!!
*  x119 -  dfbbp_1  IS MISSING !!!!
*  x121 -  dfrtp_1  IS MISSING !!!!
*  x122 -  dfsbp_1  IS MISSING !!!!
*  x123 -  dfstp_1  IS MISSING !!!!
*  x124 -  dfxbp_1  IS MISSING !!!!
*  x125 -  dlclkp_1  IS MISSING !!!!
*  x126 -  dlrbn_1  IS MISSING !!!!
*  x127 -  dlrbp_1  IS MISSING !!!!
*  x128 -  dlrtn_1  IS MISSING !!!!
*  x129 -  dlrtp_1  IS MISSING !!!!
*  x130 -  dlxbn_1  IS MISSING !!!!
*  x131 -  dlxtp_1  IS MISSING !!!!
*  x132 -  edfxbp_1  IS MISSING !!!!
*  x133 -  edfxtp_1  IS MISSING !!!!
*  x134 -  fill_1  IS MISSING !!!!
*  x120 -  dfrbp_1  IS MISSING !!!!
*  x135 -  dfrtn_1  IS MISSING !!!!
*  x136 -  dfxtp_1  IS MISSING !!!!
*  x137 -  dlxtn_1  IS MISSING !!!!
*  x138 -  dlxtp_1  IS MISSING !!!!
*  x139 -  tap_1  IS MISSING !!!!
*  x141 -  tapvgnd_1  IS MISSING !!!!
*  x142 -  tapvgnd2_1  IS MISSING !!!!
*  x143 -  tapvpwrvgnd_1  IS MISSING !!!!
*  x144 -  lpflow_bleeder_1  IS MISSING !!!!
*  x145 -  lpflow_clkbufkapwr_1  IS MISSING !!!!
*  x146 -  lpflow_clkinvkapwr_1  IS MISSING !!!!
*  x147 -  lpflow_inputiso0n_1  IS MISSING !!!!
*  x148 -  lpflow_inputiso0p_1  IS MISSING !!!!
*  x149 -  lpflow_inputiso1n_1  IS MISSING !!!!
*  x150 -  lpflow_inputiso1p_1  IS MISSING !!!!
*  x151 -  lpflow_inputisolatch_1  IS MISSING !!!!
*  x152 -  lpflow_isobufsrc_1  IS MISSING !!!!
*  x153 -  lpflow_lsbuf_lh_isowell_tap_1  IS MISSING !!!!
*  x154 -  lpflow_lsbuf_lh_hl_isowell_tap_1  IS MISSING !!!!
*  p454 -  lab_pin  IS MISSING !!!!
*  p179 -  lab_pin  IS MISSING !!!!
*  p455 -  lab_pin  IS MISSING !!!!
*  p456 -  lab_pin  IS MISSING !!!!
*  p457 -  lab_pin  IS MISSING !!!!
*  p458 -  lab_pin  IS MISSING !!!!
*  p459 -  lab_pin  IS MISSING !!!!
*  p460 -  lab_pin  IS MISSING !!!!
*  p461 -  lab_pin  IS MISSING !!!!
*  p462 -  lab_pin  IS MISSING !!!!
*  p463 -  lab_pin  IS MISSING !!!!
*  p464 -  lab_pin  IS MISSING !!!!
*  p465 -  lab_pin  IS MISSING !!!!
*  p466 -  lab_pin  IS MISSING !!!!
*  p467 -  lab_pin  IS MISSING !!!!
*  p468 -  lab_pin  IS MISSING !!!!
*  p469 -  lab_pin  IS MISSING !!!!
*  p470 -  lab_pin  IS MISSING !!!!
*  p471 -  lab_pin  IS MISSING !!!!
*  p472 -  lab_pin  IS MISSING !!!!
*  p473 -  lab_pin  IS MISSING !!!!
*  p474 -  lab_pin  IS MISSING !!!!
*  p475 -  lab_pin  IS MISSING !!!!
*  p476 -  lab_pin  IS MISSING !!!!
*  p477 -  lab_pin  IS MISSING !!!!
*  p478 -  lab_pin  IS MISSING !!!!
*  p479 -  lab_pin  IS MISSING !!!!
*  p480 -  lab_pin  IS MISSING !!!!
*  p481 -  lab_pin  IS MISSING !!!!
*  p482 -  lab_pin  IS MISSING !!!!
*  p483 -  lab_pin  IS MISSING !!!!
*  p484 -  lab_pin  IS MISSING !!!!
*  p485 -  lab_pin  IS MISSING !!!!
*  p486 -  lab_pin  IS MISSING !!!!
*  p487 -  lab_pin  IS MISSING !!!!
*  p488 -  lab_pin  IS MISSING !!!!
*  p489 -  lab_pin  IS MISSING !!!!
*  p490 -  lab_pin  IS MISSING !!!!
*  p491 -  lab_pin  IS MISSING !!!!
*  p492 -  lab_pin  IS MISSING !!!!
*  p493 -  lab_pin  IS MISSING !!!!
*  p494 -  lab_pin  IS MISSING !!!!
*  p495 -  lab_pin  IS MISSING !!!!
*  p496 -  lab_pin  IS MISSING !!!!
*  p497 -  lab_pin  IS MISSING !!!!
*  p498 -  lab_pin  IS MISSING !!!!
*  p499 -  lab_pin  IS MISSING !!!!
*  p500 -  lab_pin  IS MISSING !!!!
*  p501 -  lab_pin  IS MISSING !!!!
*  p502 -  lab_pin  IS MISSING !!!!
*  p503 -  lab_pin  IS MISSING !!!!
*  p504 -  lab_pin  IS MISSING !!!!
*  p505 -  lab_pin  IS MISSING !!!!
*  p506 -  lab_pin  IS MISSING !!!!
*  p507 -  lab_pin  IS MISSING !!!!
*  p508 -  lab_pin  IS MISSING !!!!
*  p509 -  lab_pin  IS MISSING !!!!
*  p510 -  lab_pin  IS MISSING !!!!
*  p511 -  lab_pin  IS MISSING !!!!
*  p512 -  lab_pin  IS MISSING !!!!
*  p513 -  lab_pin  IS MISSING !!!!
*  p514 -  lab_pin  IS MISSING !!!!
*  p515 -  lab_pin  IS MISSING !!!!
*  p516 -  lab_pin  IS MISSING !!!!
*  p517 -  lab_pin  IS MISSING !!!!
*  p518 -  lab_pin  IS MISSING !!!!
*  p519 -  lab_pin  IS MISSING !!!!
*  p520 -  lab_pin  IS MISSING !!!!
*  p521 -  lab_pin  IS MISSING !!!!
*  p522 -  lab_pin  IS MISSING !!!!
*  p523 -  lab_pin  IS MISSING !!!!
*  p524 -  lab_pin  IS MISSING !!!!
*  p525 -  lab_pin  IS MISSING !!!!
*  p526 -  lab_pin  IS MISSING !!!!
*  p527 -  lab_pin  IS MISSING !!!!
*  p528 -  lab_pin  IS MISSING !!!!
*  p529 -  lab_pin  IS MISSING !!!!
*  p530 -  lab_pin  IS MISSING !!!!
*  p531 -  lab_pin  IS MISSING !!!!
*  p532 -  lab_pin  IS MISSING !!!!
*  p533 -  lab_pin  IS MISSING !!!!
*  p534 -  lab_pin  IS MISSING !!!!
*  p535 -  lab_pin  IS MISSING !!!!
*  p536 -  lab_pin  IS MISSING !!!!
*  p537 -  lab_pin  IS MISSING !!!!
*  p538 -  lab_pin  IS MISSING !!!!
*  p539 -  lab_pin  IS MISSING !!!!
*  p540 -  lab_pin  IS MISSING !!!!
*  p541 -  lab_pin  IS MISSING !!!!
*  p542 -  lab_pin  IS MISSING !!!!
*  p543 -  lab_pin  IS MISSING !!!!
*  p544 -  lab_pin  IS MISSING !!!!
*  p545 -  lab_pin  IS MISSING !!!!
*  p546 -  lab_pin  IS MISSING !!!!
*  p547 -  lab_pin  IS MISSING !!!!
*  p548 -  lab_pin  IS MISSING !!!!
*  p549 -  lab_pin  IS MISSING !!!!
*  p550 -  lab_pin  IS MISSING !!!!
*  p551 -  lab_pin  IS MISSING !!!!
*  p552 -  lab_pin  IS MISSING !!!!
*  p553 -  lab_pin  IS MISSING !!!!
*  p554 -  lab_pin  IS MISSING !!!!
*  p555 -  lab_pin  IS MISSING !!!!
*  p556 -  lab_pin  IS MISSING !!!!
*  p557 -  lab_pin  IS MISSING !!!!
*  p558 -  lab_pin  IS MISSING !!!!
*  p559 -  lab_pin  IS MISSING !!!!
*  p560 -  lab_pin  IS MISSING !!!!
*  p561 -  lab_pin  IS MISSING !!!!
*  p562 -  lab_pin  IS MISSING !!!!
*  p563 -  lab_pin  IS MISSING !!!!
*  p564 -  lab_pin  IS MISSING !!!!
*  p565 -  lab_pin  IS MISSING !!!!
*  p566 -  lab_pin  IS MISSING !!!!
*  p567 -  lab_pin  IS MISSING !!!!
*  p568 -  lab_pin  IS MISSING !!!!
*  p569 -  lab_pin  IS MISSING !!!!
*  p570 -  lab_pin  IS MISSING !!!!
*  p571 -  lab_pin  IS MISSING !!!!
*  p572 -  lab_pin  IS MISSING !!!!
*  p573 -  lab_pin  IS MISSING !!!!
*  p574 -  lab_pin  IS MISSING !!!!
*  p575 -  lab_pin  IS MISSING !!!!
*  p576 -  lab_pin  IS MISSING !!!!
*  p577 -  lab_pin  IS MISSING !!!!
*  p578 -  lab_pin  IS MISSING !!!!
*  p579 -  lab_pin  IS MISSING !!!!
*  p580 -  lab_pin  IS MISSING !!!!
*  p581 -  lab_pin  IS MISSING !!!!
*  p582 -  lab_pin  IS MISSING !!!!
*  p583 -  lab_pin  IS MISSING !!!!
*  p584 -  lab_pin  IS MISSING !!!!
*  p585 -  lab_pin  IS MISSING !!!!
*  p586 -  lab_pin  IS MISSING !!!!
*  p587 -  lab_pin  IS MISSING !!!!
*  p588 -  lab_pin  IS MISSING !!!!
*  p589 -  lab_pin  IS MISSING !!!!
*  p590 -  lab_pin  IS MISSING !!!!
*  p591 -  lab_pin  IS MISSING !!!!
*  p592 -  lab_pin  IS MISSING !!!!
*  p593 -  lab_pin  IS MISSING !!!!
*  p594 -  lab_pin  IS MISSING !!!!
*  p595 -  lab_pin  IS MISSING !!!!
*  p596 -  lab_pin  IS MISSING !!!!
*  p597 -  lab_pin  IS MISSING !!!!
*  p598 -  lab_pin  IS MISSING !!!!
*  p599 -  lab_pin  IS MISSING !!!!
*  p600 -  lab_pin  IS MISSING !!!!
*  p601 -  lab_pin  IS MISSING !!!!
*  p602 -  lab_pin  IS MISSING !!!!
*  p603 -  lab_pin  IS MISSING !!!!
*  p604 -  lab_pin  IS MISSING !!!!
*  p605 -  lab_pin  IS MISSING !!!!
*  p606 -  lab_pin  IS MISSING !!!!
*  p607 -  lab_pin  IS MISSING !!!!
*  p608 -  lab_pin  IS MISSING !!!!
*  p609 -  lab_pin  IS MISSING !!!!
*  p610 -  lab_pin  IS MISSING !!!!
*  p611 -  lab_pin  IS MISSING !!!!
*  p612 -  lab_pin  IS MISSING !!!!
*  p613 -  lab_pin  IS MISSING !!!!
*  p614 -  lab_pin  IS MISSING !!!!
*  p615 -  lab_pin  IS MISSING !!!!
*  p616 -  lab_pin  IS MISSING !!!!
*  p617 -  lab_pin  IS MISSING !!!!
*  p618 -  lab_pin  IS MISSING !!!!
*  p619 -  lab_pin  IS MISSING !!!!
*  p620 -  lab_pin  IS MISSING !!!!
*  p621 -  lab_pin  IS MISSING !!!!
*  p622 -  lab_pin  IS MISSING !!!!
*  p623 -  lab_pin  IS MISSING !!!!
*  p624 -  lab_pin  IS MISSING !!!!
*  p625 -  lab_pin  IS MISSING !!!!
*  p626 -  lab_pin  IS MISSING !!!!
*  p627 -  lab_pin  IS MISSING !!!!
*  p628 -  lab_pin  IS MISSING !!!!
*  p629 -  lab_pin  IS MISSING !!!!
*  p630 -  lab_pin  IS MISSING !!!!
*  p631 -  lab_pin  IS MISSING !!!!
*  p632 -  lab_pin  IS MISSING !!!!
*  p633 -  lab_pin  IS MISSING !!!!
*  p634 -  lab_pin  IS MISSING !!!!
*  p635 -  lab_pin  IS MISSING !!!!
*  p636 -  lab_pin  IS MISSING !!!!
*  p637 -  lab_pin  IS MISSING !!!!
*  p638 -  lab_pin  IS MISSING !!!!
*  p639 -  lab_pin  IS MISSING !!!!
*  p640 -  lab_pin  IS MISSING !!!!
*  p641 -  lab_pin  IS MISSING !!!!
*  p642 -  lab_pin  IS MISSING !!!!
*  p643 -  lab_pin  IS MISSING !!!!
*  p644 -  lab_pin  IS MISSING !!!!
*  x155 -  macro_sparecell  IS MISSING !!!!
*  x156 -  clkinvlp_2  IS MISSING !!!!
*  x157 -  lpflow_lsbuf_lh_isowell_tap_4  IS MISSING !!!!
*  x158 -  diode_2  IS MISSING !!!!
*  x159 -  lpflow_decapkapwr_3  IS MISSING !!!!
*  x160 -  lpflow_isobufsrckapwr_16  IS MISSING !!!!
*  x161 -  decap_3  IS MISSING !!!!
*  x162 -  bufbuf_8  IS MISSING !!!!
*  x163 -  bufinv_8  IS MISSING !!!!
*  x164 -  probe_p_8  IS MISSING !!!!
*  x165 -  probec_p_8  IS MISSING !!!!
*  p645 -  lab_pin  IS MISSING !!!!
*  p646 -  lab_pin  IS MISSING !!!!
*  p647 -  lab_pin  IS MISSING !!!!
*  p648 -  lab_pin  IS MISSING !!!!
*  p649 -  lab_pin  IS MISSING !!!!
*  p650 -  lab_pin  IS MISSING !!!!
*  p651 -  lab_pin  IS MISSING !!!!
*  p652 -  lab_pin  IS MISSING !!!!
*  p653 -  lab_pin  IS MISSING !!!!
*  p654 -  lab_pin  IS MISSING !!!!
*  p655 -  lab_pin  IS MISSING !!!!
*  p656 -  lab_pin  IS MISSING !!!!
*  p657 -  lab_pin  IS MISSING !!!!
*  p658 -  lab_pin  IS MISSING !!!!
*  p659 -  lab_pin  IS MISSING !!!!
*  p660 -  lab_pin  IS MISSING !!!!
*  p661 -  lab_pin  IS MISSING !!!!
*  p662 -  lab_pin  IS MISSING !!!!
*  p663 -  lab_pin  IS MISSING !!!!
*  p664 -  lab_pin  IS MISSING !!!!
.ends
