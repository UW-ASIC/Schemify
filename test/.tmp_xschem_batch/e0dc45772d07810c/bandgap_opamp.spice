** sch_path: /home/omare/Documents/UWASIC/Schemify/test/examples/xschem_sky130/sky130_tests/bandgap_opamp.sch
.subckt bandgap_opamp EN_N MINUS PLUS DIFFOUT VCC VSS ADJ START

*  l1 -  title  IS MISSING !!!!
*  p93 -  ipin  IS MISSING !!!!
*  p94 -  ipin  IS MISSING !!!!
*  p95 -  ipin  IS MISSING !!!!
*  p96 -  ipin  IS MISSING !!!!
*  p97 -  ipin  IS MISSING !!!!
*  p116 -  opin  IS MISSING !!!!
*  p20 -  lab_pin  IS MISSING !!!!
*  p21 -  lab_pin  IS MISSING !!!!
*  p22 -  lab_pin  IS MISSING !!!!
*  p23 -  lab_pin  IS MISSING !!!!
*  p24 -  lab_pin  IS MISSING !!!!
*  p25 -  lab_pin  IS MISSING !!!!
*  p26 -  lab_pin  IS MISSING !!!!
*  l9 -  lab_pin  IS MISSING !!!!
*  l11 -  lab_pin  IS MISSING !!!!
*  l12 -  lab_pin  IS MISSING !!!!
*  C6 -  parax_cap  IS MISSING !!!!
*  l14 -  lab_pin  IS MISSING !!!!
*  M4 -  pfet_01v8  IS MISSING !!!!
*  M18 -  nfet_01v8_lvt  IS MISSING !!!!
*  M2 -  nfet_01v8_lvt  IS MISSING !!!!
*  M20 -  pfet_01v8_lvt  IS MISSING !!!!
*  M6 -  pfet_01v8_lvt  IS MISSING !!!!
*  h3 -  launcher  IS MISSING !!!!
*  l3 -  lab_pin  IS MISSING !!!!
*  v1 -  ammeter  IS MISSING !!!!
*  C4 -  parax_cap  IS MISSING !!!!
*  C1 -  parax_cap  IS MISSING !!!!
*  p2 -  lab_pin  IS MISSING !!!!
*  l10 -  lab_pin  IS MISSING !!!!
*  C5 -  parax_cap  IS MISSING !!!!
*  M11 -  nfet_01v8_lvt  IS MISSING !!!!
*  v2 -  ammeter  IS MISSING !!!!
*  p3 -  lab_pin  IS MISSING !!!!
*  l2 -  lab_pin  IS MISSING !!!!
*  p4 -  lab_pin  IS MISSING !!!!
*  l4 -  lab_pin  IS MISSING !!!!
*  M5 -  pfet_01v8_lvt  IS MISSING !!!!
*  v3 -  ammeter  IS MISSING !!!!
*  v4 -  ammeter  IS MISSING !!!!
*  v5 -  ammeter  IS MISSING !!!!
*  v6 -  ammeter  IS MISSING !!!!
*  l5 -  lab_pin  IS MISSING !!!!
*  p5 -  lab_pin  IS MISSING !!!!
*  M7 -  nfet_01v8  IS MISSING !!!!
*  l6 -  lab_pin  IS MISSING !!!!
*  p6 -  lab_pin  IS MISSING !!!!
*  p7 -  lab_pin  IS MISSING !!!!
*  l7 -  lab_pin  IS MISSING !!!!
*  M1 -  pfet_01v8  IS MISSING !!!!
*  p8 -  lab_pin  IS MISSING !!!!
*  M8 -  pfet_01v8_lvt  IS MISSING !!!!
*  p9 -  lab_pin  IS MISSING !!!!
*  M9 -  nfet_01v8  IS MISSING !!!!
*  p10 -  lab_pin  IS MISSING !!!!
*  M10 -  nfet_01v8  IS MISSING !!!!
*  l8 -  lab_pin  IS MISSING !!!!
*  p11 -  lab_pin  IS MISSING !!!!
*  p12 -  ipin  IS MISSING !!!!
*  x1 -  not  IS MISSING !!!!
*  p15 -  lab_pin  IS MISSING !!!!
*  p16 -  lab_pin  IS MISSING !!!!
*  p17 -  lab_pin  IS MISSING !!!!
*  p18 -  lab_pin  IS MISSING !!!!
*  p19 -  ipin  IS MISSING !!!!
*  p27 -  lab_pin  IS MISSING !!!!
*  x3 -  passgate_nlvt  IS MISSING !!!!
*  p29 -  lab_pin  IS MISSING !!!!
*  h2 -  launcher  IS MISSING !!!!
*  M3 -  pfet_01v8  IS MISSING !!!!
*  C2 -  cap_mim_m3_2  IS MISSING !!!!
*  l16 -  lab_pin  IS MISSING !!!!
*  R5 -  res_xhigh_po_0p69  IS MISSING !!!!
.ends
