** sch_path: /nix/store/qriw4afhakn3sqg2al06kdyr745hx86w-xschem-3.4.7/share/doc/xschem/examples/test_jfet.sch
.subckt test_jfet

J1 net1 net2 GND 2N3459 area=1 m=1
* noconn GND
* noconn D
* noconn G
Vgate net2 G 0
.save i(vgate)
Vdrain D net1 0
.save i(vdrain)
J2 net4 net3 GND 2N2609 area=1 m=1
Vgate1 net3 G1 0
.save i(vgate1)
Vdrain1 net4 D1 0
.save i(vdrain1)
E1 D1 GND D GND -1
E2 G1 GND G GND -1
**** begin user architecture code

VG G 0 dc 0
VD D 0 dc 0

.options savecurrents
.control
  save all
  dc VD 0 20 0.01 VG 0 -1 -0.1
  write test_jfet.raw
  quit 0
.endc

.MODEL 2N3459 NJF(VTO=-1.4 BETA=1.265m BETATCE=-0.5 LAMBDA=4m RD=1 RS=1 CGS=2.916p CGD=2.8p PB=0.5 IS=114.5f XTI=3 AF=1 FC=0.5 N=1 NR=2)
.model 2N2609 PJF (Beta=3.2m Betatce=-500m Rd=1 Rs=1 Lambda=18.5m Vto=-1.408 Vtotc=-2.5m Is=461.5f Isr=4.402p N=1 Nr=2 Xti=3 Alpha=32.54u Vk=393.2 Cgd=6.5p M=278.9m Pb=1 Fc=500m Cgs=9p Kf=0.2062f Af=1)

**** end user architecture code
.ends
