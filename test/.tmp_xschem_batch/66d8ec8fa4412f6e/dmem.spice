** sch_path: /home/omare/Documents/UWASIC/Schemify/test/examples/xschem_sky130/mips_cpu/dmem.sch
.subckt dmem clk we rdata[31] rdata[30] rdata[29] rdata[28] rdata[27] rdata[26] rdata[25] rdata[24] rdata[23] rdata[22] rdata[21]
+ rdata[20] rdata[19] rdata[18] rdata[17] rdata[16] rdata[15] rdata[14] rdata[13] rdata[12] rdata[11] rdata[10] rdata[9] rdata[8] rdata[7]
+ rdata[6] rdata[5] rdata[4] rdata[3] rdata[2] rdata[1] rdata[0] addr[31] addr[30] addr[29] addr[28] addr[27] addr[26] addr[25] addr[24]
+ addr[23] addr[22] addr[21] addr[20] addr[19] addr[18] addr[17] addr[16] addr[15] addr[14] addr[13] addr[12] addr[11] addr[10] addr[9]
+ addr[8] addr[7] addr[6] addr[5] addr[4] addr[3] addr[2] addr[1] addr[0] wdata[31] wdata[30] wdata[29] wdata[28] wdata[27] wdata[26]
+ wdata[25] wdata[24] wdata[23] wdata[22] wdata[21] wdata[20] wdata[19] wdata[18] wdata[17] wdata[16] wdata[15] wdata[14] wdata[13] wdata[12]
+ wdata[11] wdata[10] wdata[9] wdata[8] wdata[7] wdata[6] wdata[5] wdata[4] wdata[3] wdata[2] wdata[1] wdata[0]

*  p1 -  ipin  IS MISSING !!!!
*  l1 -  title  IS MISSING !!!!
*  p10 -  ipin  IS MISSING !!!!
*  p11 -  ipin  IS MISSING !!!!
*  p12 -  ipin  IS MISSING !!!!
*  p13 -  opin  IS MISSING !!!!
*  x1 -    IS MISSING !!!!
*  l2 -  noconn  IS MISSING !!!!
*  l3 -  noconn  IS MISSING !!!!
*  l4 -  noconn  IS MISSING !!!!
*  l5 -  noconn  IS MISSING !!!!
*  l6 -  noconn  IS MISSING !!!!
.ends
