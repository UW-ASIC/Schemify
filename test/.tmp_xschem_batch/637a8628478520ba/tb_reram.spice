** sch_path: /home/omare/Documents/UWASIC/Schemify/test/examples/xschem_sky130/sky130_tests/tb_reram.sch
.subckt tb_reram

*  NGSPICE -  code_shown  IS MISSING !!!!
*  l1 -  title  IS MISSING !!!!
*  p3 -  lab_pin  IS MISSING !!!!
*  p1 -  lab_pin  IS MISSING !!!!
*  h1 -  launcher  IS MISSING !!!!
*  V1 -  vsource  IS MISSING !!!!
*  h5 -  launcher  IS MISSING !!!!
*  R1 -  reram  IS MISSING !!!!
*  Vreram -  ammeter  IS MISSING !!!!
*  R2 -  res  IS MISSING !!!!
*  p2 -  lab_pin  IS MISSING !!!!
.ends
