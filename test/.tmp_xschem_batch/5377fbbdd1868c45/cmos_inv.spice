** sch_path: /nix/store/qriw4afhakn3sqg2al06kdyr745hx86w-xschem-3.4.7/share/doc/xschem/examples/cmos_inv.sch
.subckt cmos_inv Z A
*.PININFO Z:O A:I
M2 net1 A VDD VDD p w=WP l=LLP m=1
M1 D A 0 0 n w=WN l=LLN m=1
R1 net2 D 10 m=1
V1 net1 D 0
.save i(v1)
Vmeas net2 Z 0
.save i(vmeas)
.ends
.GLOBAL VDD
