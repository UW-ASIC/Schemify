** sch_path: /home/omare/Documents/UWASIC/Schemify/test/examples/xschem_sky130/sky130_tests/charge_pump2.sch
.subckt charge_pump2 VCC HV CK CKN

*  l1 -  title  IS MISSING !!!!
*  M8 -  nfet_g5v0d10v5  IS MISSING !!!!
*  M9 -  nfet_g5v0d10v5  IS MISSING !!!!
*  M10 -  pfet_g5v0d10v5  IS MISSING !!!!
*  M11 -  pfet_g5v0d10v5  IS MISSING !!!!
*  C7 -  cap_mim_m3_1  IS MISSING !!!!
*  C8 -  cap_mim_m3_1  IS MISSING !!!!
*  p20 -  ipin  IS MISSING !!!!
*  M12 -  nfet_g5v0d10v5  IS MISSING !!!!
*  M13 -  nfet_g5v0d10v5  IS MISSING !!!!
*  M14 -  pfet_g5v0d10v5  IS MISSING !!!!
*  M15 -  pfet_g5v0d10v5  IS MISSING !!!!
*  C9 -  cap_mim_m3_1  IS MISSING !!!!
*  C10 -  cap_mim_m3_1  IS MISSING !!!!
*  p21 -  iopin  IS MISSING !!!!
*  p22 -  lab_wire  IS MISSING !!!!
*  x12 -  inv_6  IS MISSING !!!!
*  x1 -  inv_6  IS MISSING !!!!
*  x2 -  inv_6  IS MISSING !!!!
*  x3 -  inv_6  IS MISSING !!!!
*  p24 -  ipin  IS MISSING !!!!
*  p25 -  ipin  IS MISSING !!!!
*  M1 -  pfet_g5v0d10v5  IS MISSING !!!!
*  M2 -  pfet_g5v0d10v5  IS MISSING !!!!
*  C1 -  cap_mim_m3_1  IS MISSING !!!!
*  C2 -  cap_mim_m3_1  IS MISSING !!!!
*  M3 -  pfet_g5v0d10v5  IS MISSING !!!!
*  M4 -  pfet_g5v0d10v5  IS MISSING !!!!
*  C3 -  cap_mim_m3_1  IS MISSING !!!!
*  C4 -  cap_mim_m3_1  IS MISSING !!!!
*  x4 -  inv_2  IS MISSING !!!!
*  x5 -  inv_2  IS MISSING !!!!
*  x6 -  inv_2  IS MISSING !!!!
*  x7 -  inv_2  IS MISSING !!!!
*  C5 -  cap_mim_m3_1  IS MISSING !!!!
*  C6 -  cap_mim_m3_1  IS MISSING !!!!
*  x8 -  inv_2  IS MISSING !!!!
*  x9 -  inv_2  IS MISSING !!!!
*  M5 -  nfet_g5v0d10v5  IS MISSING !!!!
*  M6 -  nfet_g5v0d10v5  IS MISSING !!!!
*  C11 -  cap_mim_m3_1  IS MISSING !!!!
*  C12 -  cap_mim_m3_1  IS MISSING !!!!
*  x10 -  inv_2  IS MISSING !!!!
*  x11 -  inv_2  IS MISSING !!!!
*  M7 -  nfet_g5v0d10v5  IS MISSING !!!!
*  M16 -  nfet_g5v0d10v5  IS MISSING !!!!
*  p1 -  lab_wire  IS MISSING !!!!
*  p2 -  lab_wire  IS MISSING !!!!
*  p3 -  lab_wire  IS MISSING !!!!
*  p4 -  lab_wire  IS MISSING !!!!
*  p5 -  lab_wire  IS MISSING !!!!
*  p6 -  lab_wire  IS MISSING !!!!
*  p7 -  lab_wire  IS MISSING !!!!
*  p8 -  lab_wire  IS MISSING !!!!
*  p9 -  lab_wire  IS MISSING !!!!
*  p10 -  lab_wire  IS MISSING !!!!
*  p11 -  lab_wire  IS MISSING !!!!
*  p12 -  lab_wire  IS MISSING !!!!
*  h2 -  launcher  IS MISSING !!!!
.ends
