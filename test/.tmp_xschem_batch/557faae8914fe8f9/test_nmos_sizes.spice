** sch_path: /home/omare/Documents/UWASIC/Schemify/test/examples/xschem_sky130/sky130_tests/test_nmos_sizes.sch
.subckt test_nmos_sizes

*  l1 -  title  IS MISSING !!!!
*  STIMULI -  code  IS MISSING !!!!
*  p194 -  lab_pin  IS MISSING !!!!
*  p197 -  lab_pin  IS MISSING !!!!
*  p1 -  lab_pin  IS MISSING !!!!
*  p2 -  lab_pin  IS MISSING !!!!
*  M1 -  nfet_01v8_lvt  IS MISSING !!!!
*  p3 -  lab_pin  IS MISSING !!!!
*  p4 -  lab_pin  IS MISSING !!!!
*  p5 -  lab_pin  IS MISSING !!!!
*  p6 -  lab_pin  IS MISSING !!!!
*  M2 -  nfet_01v8_lvt  IS MISSING !!!!
*  V2 -  ammeter  IS MISSING !!!!
*  V1 -  ammeter  IS MISSING !!!!
*  p7 -  lab_pin  IS MISSING !!!!
?
*  p8 -  lab_pin  IS MISSING !!!!
*  l2 -  noconn  IS MISSING !!!!
.ends
