** sch_path: /home/omare/Documents/UWASIC/Schemify/test/examples/xschem_sky130/sky130_tests/LACG.sch
.subckt LACG

*  x1 -  xor2_1  IS MISSING !!!!
*  x2 -  dlxtp_1  IS MISSING !!!!
*  x3 -  dlxtn_1  IS MISSING !!!!
*  x4 -  dlxtn_1  IS MISSING !!!!
*  x5 -  and2_1  IS MISSING !!!!
*  V1 -  vsource  IS MISSING !!!!
*  l1 -  gnd  IS MISSING !!!!
*  l2 -  lab_wire  IS MISSING !!!!
*  l3 -  lab_wire  IS MISSING !!!!
*  l4 -  lab_wire  IS MISSING !!!!
*  x6 -  xor2_1  IS MISSING !!!!
*  x7 -  dlxtp_1  IS MISSING !!!!
*  x8 -  dlxtn_1  IS MISSING !!!!
*  x9 -  dlxtn_1  IS MISSING !!!!
*  x10 -  and2_1  IS MISSING !!!!
*  l5 -  lab_wire  IS MISSING !!!!
*  l6 -  lab_wire  IS MISSING !!!!
*  l7 -  lab_wire  IS MISSING !!!!
*  x11 -  xor2_1  IS MISSING !!!!
*  x12 -  dlxtp_1  IS MISSING !!!!
*  x13 -  dlxtn_1  IS MISSING !!!!
*  x14 -  dlxtn_1  IS MISSING !!!!
*  x15 -  and2_1  IS MISSING !!!!
*  l8 -  lab_wire  IS MISSING !!!!
*  l9 -  lab_wire  IS MISSING !!!!
*  l10 -  lab_wire  IS MISSING !!!!
*  V2 -  vsource  IS MISSING !!!!
*  l11 -  gnd  IS MISSING !!!!
*  V3 -  vsource  IS MISSING !!!!
*  l12 -  gnd  IS MISSING !!!!
*  x17 -  xor2_1  IS MISSING !!!!
*  x18 -  dlxtp_1  IS MISSING !!!!
*  x19 -  dlxtn_1  IS MISSING !!!!
*  x20 -  dlxtn_1  IS MISSING !!!!
*  x21 -  and2_1  IS MISSING !!!!
*  l14 -  lab_wire  IS MISSING !!!!
*  l16 -  lab_wire  IS MISSING !!!!
*  x22 -  and2_1  IS MISSING !!!!
*  x23 -  inv_1  IS MISSING !!!!
*  x24 -  and3_1  IS MISSING !!!!
*  x25 -  xor2_1  IS MISSING !!!!
*  x26 -  dlxtp_1  IS MISSING !!!!
*  x27 -  dlxtn_1  IS MISSING !!!!
*  x28 -  dlxtn_1  IS MISSING !!!!
*  x29 -  and2_1  IS MISSING !!!!
*  l17 -  lab_wire  IS MISSING !!!!
*  l18 -  lab_wire  IS MISSING !!!!
*  l19 -  lab_wire  IS MISSING !!!!
*  C1 -  capa  IS MISSING !!!!
*  l13 -  gnd  IS MISSING !!!!
*  C2 -  capa  IS MISSING !!!!
*  l20 -  gnd  IS MISSING !!!!
*  V4 -  vsource  IS MISSING !!!!
*  l21 -  gnd  IS MISSING !!!!
*  s1 -  code_shown  IS MISSING !!!!
*  V5 -  vsource  IS MISSING !!!!
*  l22 -  gnd  IS MISSING !!!!
*  l23 -  lab_wire  IS MISSING !!!!
*  x16 -  or3_1  IS MISSING !!!!
*  x30 -  and3_1  IS MISSING !!!!
*  l25 -  lab_wire  IS MISSING !!!!
*  l24 -  lab_wire  IS MISSING !!!!
*  l26 -  lab_wire  IS MISSING !!!!
*  l27 -  lab_wire  IS MISSING !!!!
*  l28 -  lab_wire  IS MISSING !!!!
*  l29 -  lab_wire  IS MISSING !!!!
*  l15 -  lab_wire  IS MISSING !!!!
*  l31 -  lab_wire  IS MISSING !!!!
*  l32 -  lab_wire  IS MISSING !!!!
*  l33 -  lab_wire  IS MISSING !!!!
*  l34 -  title  IS MISSING !!!!
*  l30 -  lab_wire  IS MISSING !!!!
?
.ends
