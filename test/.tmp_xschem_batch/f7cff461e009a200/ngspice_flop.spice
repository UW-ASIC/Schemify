** sch_path: /home/omare/Documents/UWASIC/Schemify/test/examples/xschem_sky130/sky130_tests/ngspice_flop.sch
.subckt ngspice_flop A_OUT A_IN A_CLK A_GND A_VDD

*  p1 -  iopin  IS MISSING !!!!
*  p2 -  ipin  IS MISSING !!!!
*  p3 -  opin  IS MISSING !!!!
*  p4 -  ipin  IS MISSING !!!!
*  p5 -  iopin  IS MISSING !!!!
*  l1 -  title  IS MISSING !!!!
*  l2 -  noconn  IS MISSING !!!!
*  l3 -  noconn  IS MISSING !!!!
*  l4 -  noconn  IS MISSING !!!!
*  l5 -  noconn  IS MISSING !!!!
*  l6 -  noconn  IS MISSING !!!!
**** begin user architecture code
.model todig_3v3 adc_bridge(in_high=2.2 in_low=1.1
+ rise_delay=10n fall_delay=10n)
.model toana_3v3 dac_bridge(out_high=3.3 out_low=0)
.model ddflop d_dff(ic=0 rise_delay=1n fall_delay=1n)
AA2D1 [A_GND] [d_gnd] todig_3v3
AA2D2 [A_IN] [d_in] todig_3v3
AA2D3 [A_CLK] [d_clk] todig_3v3
A1 d_in d_clk d_gnd d_gnd d_out NULL ddflop
AD2A1 [d_out] [A_OUT] toana_3v3

**** end user architecture code
.ends
