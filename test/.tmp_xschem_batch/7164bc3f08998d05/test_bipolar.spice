** sch_path: /home/omare/Documents/UWASIC/Schemify/test/examples/xschem_sky130/sky130_tests/test_bipolar.sch
.subckt test_bipolar

*  NGSPICE -  code_shown  IS MISSING !!!!
*  l1 -  title  IS MISSING !!!!
*  Q1 -  pnp_05v5  IS MISSING !!!!
*  Vc1 -  ammeter  IS MISSING !!!!
*  Vb1 -  ammeter  IS MISSING !!!!
*  p3 -  lab_pin  IS MISSING !!!!
*  p4 -  lab_pin  IS MISSING !!!!
*  I0 -  isource  IS MISSING !!!!
*  p1 -  lab_pin  IS MISSING !!!!
*  Ve1 -  ammeter  IS MISSING !!!!
*  CORNER -  corner  IS MISSING !!!!
*  h4 -  launcher  IS MISSING !!!!
*  r14 -  ngspice_get_value  IS MISSING !!!!
*  r1 -  ngspice_get_expr  IS MISSING !!!!
*  p1 -  spice_probe_vdiff  IS MISSING !!!!
*  h1 -  launcher  IS MISSING !!!!
*  p2 -  lab_pin  IS MISSING !!!!
*  Ve2 -  ammeter  IS MISSING !!!!
*  Vc2 -  ammeter  IS MISSING !!!!
*  Vb2 -  ammeter  IS MISSING !!!!
*  p5 -  lab_pin  IS MISSING !!!!
*  p6 -  lab_pin  IS MISSING !!!!
*  r2 -  ngspice_get_expr  IS MISSING !!!!
*  r3 -  ngspice_get_value  IS MISSING !!!!
*  Q2 -  npn_05v5  IS MISSING !!!!
*  p7 -  lab_pin  IS MISSING !!!!
*  F1 -  cccs  IS MISSING !!!!
.ends
