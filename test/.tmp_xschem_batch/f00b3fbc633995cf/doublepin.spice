** sch_path: /nix/store/qriw4afhakn3sqg2al06kdyr745hx86w-xschem-3.4.7/share/doc/xschem/examples/doublepin.sch
.subckt doublepin A[3] A[2] A[1] A[0] B CK RST Z
*.PININFO A[3:0]:I B:I Z:O RST:I CK:I
x2[3] A[3] Z CK RST NC4 latch
x2[2] A[2] NC1 CK RST NC5 latch
x2[1] A[1] NC2 CK RST NC6 latch
x2[0] A[0] NC3 CK RST NC7 latch
* noconn B
.ends

* expanding   symbol:  latch.sym # of pins=5
** sym_path: /nix/store/qriw4afhakn3sqg2al06kdyr745hx86w-xschem-3.4.7/share/doc/xschem/logic/latch.sym
** sch_path: /nix/store/qriw4afhakn3sqg2al06kdyr745hx86w-xschem-3.4.7/share/doc/xschem/logic/latch.sch
.subckt latch D Q G RST QN  delay=200 ps del=200
*.PININFO Q:O G:I RST:I QN:O D:I
* noconn Q
* noconn QN
* noconn RST
* noconn D
* noconn G
.ends
