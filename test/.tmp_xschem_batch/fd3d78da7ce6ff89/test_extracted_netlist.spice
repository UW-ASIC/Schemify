** sch_path: /nix/store/qriw4afhakn3sqg2al06kdyr745hx86w-xschem-3.4.7/share/doc/xschem/examples/test_extracted_netlist.sch
.subckt test_extracted_netlist

R1 MINUS C1 10k m=1
R2 OUT MINUS 100k m=1
VPP net1 net3 dc 50
VNN net3 net2 dc 50
vcurrvpp net1 VPP 0
.save i(vcurrvpp)
vcurrvnn net2 VNN 0
.save i(vcurrvnn)
vcurrvss net3 VSS 0
.save i(vcurrvss)
.save v(vpp)
.save v(vnn)
VVSS VSS 0 0
VIN IN VSS pwl 0 0 100u 0 110u 2 200u 2 210u 0 300u 0 310u -2
.save v(out)
.save v(minus)
.save v(in)
R4 VPP PLUS 100k m=1
R5 PLUS VSS 100k m=1
C1 PLUS IN 50u m=1
C4 C1 VSS 50u m=1
R13 VPP MINUS 100k m=1
RLOAD OUT VSS 4 m=1
.save v(plus)
x1 MINUS PLUS VSS OUT VPP VNN mos_power_ampli_extracted
**** begin user architecture code

.include "models_poweramp.txt"
.options method=gear savecurrents ITL4=500 ITL5=50000  CHGTOL=1e-15 TRTOL=1
.control
save all
op
write test_extracted_netlist.raw
set appendwrite
tran  100n 400u
* .FOUR 20k v(outm,outp)
* .probe i(*)
write test_extracted_netlist.raw
.endc

**** end user architecture code
.ends

* expanding   symbol:  mos_power_ampli_extracted.sym # of pins=6
** sym_path: /nix/store/qriw4afhakn3sqg2al06kdyr745hx86w-xschem-3.4.7/share/doc/xschem/examples/mos_power_ampli_extracted.sym
** sch_path: /nix/store/qriw4afhakn3sqg2al06kdyr745hx86w-xschem-3.4.7/share/doc/xschem/examples/mos_power_ampli_extracted.sch
.subckt mos_power_ampli_extracted MINUS PLUS VSS OUT VPP VNN
*.PININFO PLUS:I VPP:I VNN:I OUT:O MINUS:I VSS:I
* noconn MINUS
* noconn PLUS
* noconn VSS
* noconn VPP
* noconn VNN
* noconn OUT
**** begin user architecture code
xm2 net1 GB SB irf540 m=1
R7 GB SB 190 m=1
xm1 VPP GA SA irf540 m=1
R0 GA SA 190 m=1
R2 VPP E2 50 m=1
R3 VBOOST E1 50 m=1
Q5 C5 PLUS E9 q2n2222 area=1 m=1
Q4 net8 net2 E4 q2n2907p area=1 m=1
R9 VBOOST E4 50 m=1
Q6 C6 C2 net5 q2n2907p area=1 m=1
R4 VPP E6 50 m=1
vd OUTI net1 0
.save  i(vd)
vu SA OUTI 0
.save  i(vu)
Q1 net2 net2 E1 q2n2907p area=1 m=1
Q2 C2 C2 net4 q2n2907p area=1 m=1
Q9 C9 MINUS E9 q2n2222 area=1 m=1
R11 GB net6 1300 m=1
Q8 C8 VSS E8 q2n2907p area=1 m=1
C12 VBOOST net3 40u m=1
D0 VPP VBOOST d1n4148 area=1
R18 net3 OUTI 200 m=1
D1 VPP VBOOST d1n758
R14 B1 net7 4k m=1
Q11 GA B1 E11 q2n2907p area=1 m=1
R15 VBOOST B1 4k m=1
R5 E9 net9 120 m=1
R6 net9 net10 120 m=1
D2 VSS B3 d1n755
Q3 C3 B3 E3 q2n2222 area=1 m=1
R1 VPP B3 10k m=1
R10 E3 VSS 170 m=1
C3 B3 VSS 100n m=1
R12 C6 E8 1300 m=1
R13 C2 C9 300 m=1
Q7 C7 C9 C5 q2n2222 area=1 m=1
v0 SB VNN 0
.save  i(v0)
v1 E6 net5 0
.save  i(v1)
v2 E2 net4 0
.save  i(v2)
v3 net10 C3 0
.save  i(v3)
v4 C8 net6 0
.save  i(v4)
v5 net7 OUTI 0
.save  i(v5)
v6 net2 C7 0
.save  i(v6)
v7 net8 E11 0
.save  i(v7)
.save  v(gb)
.save  v(sb)
.save  v(ga)
.save  v(sa)
v8 OUTI OUT 0
.save  i(v8)
.save  v(ga)
.save  v(gb)
.save  v(c2)
.save  v(net2)
.save  v(c7)
.save  v(vboost)
.save  v(outi)
**** end user architecture code
.ends
