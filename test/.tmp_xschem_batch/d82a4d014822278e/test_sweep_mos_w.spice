** sch_path: /home/omare/Documents/UWASIC/Schemify/test/examples/xschem_sky130/sky130_tests/test_sweep_mos_w.sch
.subckt test_sweep_mos_w

*  V1 -  vsource  IS MISSING !!!!
*  V2 -  vsource  IS MISSING !!!!
*  l1 -  gnd  IS MISSING !!!!
*  p1 -  lab_wire  IS MISSING !!!!
*  p2 -  lab_wire  IS MISSING !!!!
*  CORNER -  corner  IS MISSING !!!!
*  l2 -  title  IS MISSING !!!!
*  COMMANDS -  simulator_commands_shown  IS MISSING !!!!
*  h5 -  launcher  IS MISSING !!!!
*  M1 -  nfet_01v8  IS MISSING !!!!
*  r11 -  ngspice_get_value  IS MISSING !!!!
*  h1 -  launcher  IS MISSING !!!!
*  annot1 -  annotate_fet_params  IS MISSING !!!!
.ends
