** sch_path: /home/omare/Documents/UWASIC/Schemify/test/examples/xschem_sky130/sky130_tests/montecarlo_mismatch_sim.sch
.subckt montecarlo_mismatch_sim

*  l1 -  vdd  IS MISSING !!!!
*  l2 -  gnd  IS MISSING !!!!
*  Vprobe2 -  vsource  IS MISSING !!!!
*  VICM -  vsource  IS MISSING !!!!
*  l4 -  gnd  IS MISSING !!!!
*  C1 -  capa  IS MISSING !!!!
*  l5 -  gnd  IS MISSING !!!!
*  l6 -  vdd  IS MISSING !!!!
*  V3 -  vsource  IS MISSING !!!!
*  l7 -  gnd  IS MISSING !!!!
*  NGSPICE -  code  IS MISSING !!!!
*  CORNER -  corner  IS MISSING !!!!
*  h15 -  launcher  IS MISSING !!!!
*  p2 -  lab_pin  IS MISSING !!!!
*  l8 -  title  IS MISSING !!!!
*  x2 -  ota1tb  IS MISSING !!!!
*  h5 -  launcher  IS MISSING !!!!
*  p3 -  lab_pin  IS MISSING !!!!
.save v(net3)
.save v(net5)
.ends
