** sch_path: /home/omare/Documents/UWASIC/Schemify/test/examples/xschem_sky130/sky130_tests/n_diffamp.sch
.subckt n_diffamp OUT MINUS PLUS NBIAS

*  l1 -  title  IS MISSING !!!!
*  STIMULI -  code  IS MISSING !!!!
*  M1 -  nfet3_01v8_lvt  IS MISSING !!!!
*  M2 -  nfet3_01v8_lvt  IS MISSING !!!!
*  M3 -  pfet3_01v8_lvt  IS MISSING !!!!
*  M4 -  pfet3_01v8_lvt  IS MISSING !!!!
*  l2 -  gnd  IS MISSING !!!!
*  l3 -  vdd  IS MISSING !!!!
*  p4 -  ipin  IS MISSING !!!!
*  p1 -  ipin  IS MISSING !!!!
*  p2 -  opin  IS MISSING !!!!
*  M5 -  nfet3_01v8  IS MISSING !!!!
*  p3 -  ipin  IS MISSING !!!!
*  h2 -  launcher  IS MISSING !!!!
*  h1 -  launcher  IS MISSING !!!!
*  l4 -  lab_pin  IS MISSING !!!!
*  R1 -  res_xhigh_po_0p35  IS MISSING !!!!
*  l18 -  gnd  IS MISSING !!!!
*  l19 -  gnd  IS MISSING !!!!
*  r9 -  ngspice_get_value  IS MISSING !!!!
*  V1 -  vsource  IS MISSING !!!!
*  l9 -  gnd  IS MISSING !!!!
*  l10 -  lab_pin  IS MISSING !!!!
*  V2 -  vsource  IS MISSING !!!!
*  l11 -  gnd  IS MISSING !!!!
*  l12 -  lab_pin  IS MISSING !!!!
*  V3 -  vsource  IS MISSING !!!!
*  l13 -  gnd  IS MISSING !!!!
*  l14 -  vdd  IS MISSING !!!!
*  V4 -  vsource  IS MISSING !!!!
*  l5 -  gnd  IS MISSING !!!!
*  l6 -  lab_pin  IS MISSING !!!!
*  r10 -  ngspice_get_expr  IS MISSING !!!!
*  CORNER -  corner  IS MISSING !!!!
*  V5 -  ammeter  IS MISSING !!!!
*  r2 -  ngspice_get_expr  IS MISSING !!!!
*  annot5 -  annotate_fet_params  IS MISSING !!!!
*  annot3 -  annotate_fet_params  IS MISSING !!!!
*  annot4 -  annotate_fet_params  IS MISSING !!!!
*  annot1 -  annotate_fet_params  IS MISSING !!!!
*  annot2 -  annotate_fet_params  IS MISSING !!!!
.ends
