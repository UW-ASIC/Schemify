** sch_path: /nix/store/qriw4afhakn3sqg2al06kdyr745hx86w-xschem-3.4.7/share/doc/xschem/examples/Q2.sch
.subckt Q2 P3 P2 P1
*.PININFO P3:B P1:B P2:B
Rcx P3 C 1.716 TC1=0.113e-2 m=1
Re E P1 0.443 m=1
Rbx P2 B 0.463 TC1=0.14e-2 m=1
Q1 C B E BJTM1_Q2 area=4 m=1
D1 P2 C DiodeM1_Q2 area=1
Ccox P2 C 6.598e-14 m=1
Ceox B P1 2.417e-14 m=1
D2 B E DiodeM2_Q2 area=1
**** begin user architecture code

* This is the BJT model used in the Agilent MSA-26 model
* documented in 5980-2496E.pdf.
* Model entered 3.30.2003 by SDB
.model BJTM1_Q2   NPN(Bf=1e6 IKF=5.895e-1 ISE=2.838e-19 NE=1.006
+  VAF=44 NF=1 TF=5.37e-12 XTF=20 VTF=0.8 ITF=8.872e-1 PTF=22
+  XTB=0.7 BR=1 IKR=4.4e-2 NC=2 VAR=3.37 NR=1.005 TR=4e-9
+  EG=1.17 IS=1.79e-17 XTI=3 TNOM=21 CJC=3.717e-14
+  VJC=0.6775 MJC=0.3319 XCJC=4.398e-1 FC=0.8 CJE=3.217e-13
+  VJE=0.9907 MJE=0.5063 RB=2.325 IRB=3.272e-4 RBM=2.5e-2 KF=1.026e-24)

* This is a diode model used in the Agilent MSA-26 model
* documented in 5980-2496E.pdf.
* Model entered 3.30.2003 by SDB
.model DIODEM1_Q2   D(IS=5.62e-17 N=1 CJO=9.676e-14
+  VJ=0.729 M=0.44 FC=0.8 TNOM=21)

* This is a diode model used in the Agilent MSA-26 model
* documented in 5980-2496E.pdf.
* Model entered 3.30.2003 by SDB
.model DIODEM2_Q2   D(IS=1e-24 N=1.0029 CJO=9.023e-14
+  VJ=0.8971 M=2.292e-1 FC=0.8 TNOM=21)

**** end user architecture code
.ends
