** sch_path: /home/omare/Documents/UWASIC/Schemify/test/examples/xschem_sky130/mips_cpu/alu.sch
.subckt alu a_in[31] a_in[30] a_in[29] a_in[28] a_in[27] a_in[26] a_in[25] a_in[24] a_in[23] a_in[22] a_in[21] a_in[20] a_in[19]
+ a_in[18] a_in[17] a_in[16] a_in[15] a_in[14] a_in[13] a_in[12] a_in[11] a_in[10] a_in[9] a_in[8] a_in[7] a_in[6] a_in[5] a_in[4] a_in[3]
+ a_in[2] a_in[1] a_in[0] zero b_in[31] b_in[30] b_in[29] b_in[28] b_in[27] b_in[26] b_in[25] b_in[24] b_in[23] b_in[22] b_in[21] b_in[20]
+ b_in[19] b_in[18] b_in[17] b_in[16] b_in[15] b_in[14] b_in[13] b_in[12] b_in[11] b_in[10] b_in[9] b_in[8] b_in[7] b_in[6] b_in[5] b_in[4]
+ b_in[3] b_in[2] b_in[1] b_in[0] c_out y_out[31] y_out[30] y_out[29] y_out[28] y_out[27] y_out[26] y_out[25] y_out[24] y_out[23] y_out[22]
+ y_out[21] y_out[20] y_out[19] y_out[18] y_out[17] y_out[16] y_out[15] y_out[14] y_out[13] y_out[12] y_out[11] y_out[10] y_out[9] y_out[8]
+ y_out[7] y_out[6] y_out[5] y_out[4] y_out[3] y_out[2] y_out[1] y_out[0] f_in[2] f_in[1] f_in[0]

*  p1 -  ipin  IS MISSING !!!!
*  p4 -  opin  IS MISSING !!!!
*  l1 -  title  IS MISSING !!!!
*  x1 -    IS MISSING !!!!
*  p2 -  ipin  IS MISSING !!!!
*  p3 -  ipin  IS MISSING !!!!
*  p5 -  opin  IS MISSING !!!!
*  p6 -  opin  IS MISSING !!!!
*  l3 -  noconn  IS MISSING !!!!
*  l4 -  noconn  IS MISSING !!!!
*  l5 -  noconn  IS MISSING !!!!
*  l6 -  noconn  IS MISSING !!!!
*  l2 -  noconn  IS MISSING !!!!
*  l7 -  noconn  IS MISSING !!!!
.ends
