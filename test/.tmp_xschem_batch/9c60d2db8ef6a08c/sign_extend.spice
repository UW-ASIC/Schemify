** sch_path: /home/omare/Documents/UWASIC/Schemify/test/examples/xschem_sky130/mips_cpu/sign_extend.sch
.subckt sign_extend idata[15] idata[14] idata[13] idata[12] idata[11] idata[10] idata[9] idata[8] idata[7] idata[6] idata[5]
+ idata[4] idata[3] idata[2] idata[1] idata[0] odata[31] odata[30] odata[29] odata[28] odata[27] odata[26] odata[25] odata[24] odata[23]
+ odata[22] odata[21] odata[20] odata[19] odata[18] odata[17] odata[16] odata[15] odata[14] odata[13] odata[12] odata[11] odata[10] odata[9]
+ odata[8] odata[7] odata[6] odata[5] odata[4] odata[3] odata[2] odata[1] odata[0]

*  l1 -  title  IS MISSING !!!!
*  p7 -  opin  IS MISSING !!!!
*  p1 -  ipin  IS MISSING !!!!
*  x1 -    IS MISSING !!!!
*  l5 -  noconn  IS MISSING !!!!
*  l6 -  noconn  IS MISSING !!!!
.ends
