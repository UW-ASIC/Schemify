** sch_path: /home/omare/Documents/UWASIC/Schemify/test/examples/xschem_sky130/sky130_tests/passgate.sch
.subckt passgate Z GP A VCCBPIN modelp wp lp extra m Z GN A VSSBPIN modeln wn ln m

*  l1 -  title  IS MISSING !!!!
*  p1 -  iopin  IS MISSING !!!!
*  p2 -  iopin  IS MISSING !!!!
*  p3 -  ipin  IS MISSING !!!!
*  p4 -  ipin  IS MISSING !!!!
*  M1 -  nfet_01v8  IS MISSING !!!!
*  M2 -  pfet_01v8  IS MISSING !!!!
*  p179 -  lab_pin  IS MISSING !!!!
*  p180 -  lab_pin  IS MISSING !!!!
*  l2 -  lab_pin  IS MISSING !!!!
*  l1 -  noconn  IS MISSING !!!!
*  l2 -  lab_pin  IS MISSING !!!!
*  l3 -  noconn  IS MISSING !!!!
.ends
