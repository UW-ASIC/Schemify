** sch_path: /home/omare/Documents/UWASIC/Schemify/test/examples/xschem_sky130/xschem_verilog_import/sky130_fd_sc_hvl__lsbuflv2hv_1.sch
.subckt sky130_fd_sc_hvl__lsbuflv2hv_1 A LVPWR VGND VNB VPB VPWR X

*  p80 -  iopin  IS MISSING !!!!
*  p81 -  iopin  IS MISSING !!!!
*  p0 -  lab_pin  IS MISSING !!!!
*  p1 -  lab_pin  IS MISSING !!!!
*  p2 -  lab_pin  IS MISSING !!!!
*  p3 -  lab_pin  IS MISSING !!!!
*  X0 -  nfet_g5v0d10v5  IS MISSING !!!!
*  p4 -  lab_pin  IS MISSING !!!!
*  p5 -  lab_pin  IS MISSING !!!!
*  p6 -  lab_pin  IS MISSING !!!!
*  p7 -  lab_pin  IS MISSING !!!!
*  X1 -  nfet_g5v0d10v5  IS MISSING !!!!
*  p8 -  lab_pin  IS MISSING !!!!
*  p9 -  lab_pin  IS MISSING !!!!
*  p10 -  lab_pin  IS MISSING !!!!
*  p11 -  lab_pin  IS MISSING !!!!
*  X2 -  pfet_g5v0d10v5  IS MISSING !!!!
*  p12 -  lab_pin  IS MISSING !!!!
*  p13 -  lab_pin  IS MISSING !!!!
*  p14 -  lab_pin  IS MISSING !!!!
*  p15 -  lab_pin  IS MISSING !!!!
*  X3 -  nfet_g5v0d10v5  IS MISSING !!!!
*  p16 -  lab_pin  IS MISSING !!!!
*  p17 -  lab_pin  IS MISSING !!!!
*  p18 -  lab_pin  IS MISSING !!!!
*  p19 -  lab_pin  IS MISSING !!!!
*  X4 -  nfet_01v8  IS MISSING !!!!
*  p20 -  lab_pin  IS MISSING !!!!
*  p21 -  lab_pin  IS MISSING !!!!
*  p22 -  lab_pin  IS MISSING !!!!
*  p23 -  lab_pin  IS MISSING !!!!
*  X5 -  pfet_g5v0d10v5  IS MISSING !!!!
*  p24 -  lab_pin  IS MISSING !!!!
*  p25 -  lab_pin  IS MISSING !!!!
*  p26 -  lab_pin  IS MISSING !!!!
*  p27 -  lab_pin  IS MISSING !!!!
*  X6 -  pfet_01v8_hvt  IS MISSING !!!!
*  p28 -  lab_pin  IS MISSING !!!!
*  p29 -  lab_pin  IS MISSING !!!!
*  p30 -  lab_pin  IS MISSING !!!!
*  p31 -  lab_pin  IS MISSING !!!!
*  X7 -  nfet_g5v0d10v5  IS MISSING !!!!
*  p32 -  lab_pin  IS MISSING !!!!
*  p33 -  lab_pin  IS MISSING !!!!
*  p34 -  lab_pin  IS MISSING !!!!
*  p35 -  lab_pin  IS MISSING !!!!
*  X8 -  nfet_g5v0d10v5  IS MISSING !!!!
*  p36 -  lab_pin  IS MISSING !!!!
*  p37 -  lab_pin  IS MISSING !!!!
*  p38 -  lab_pin  IS MISSING !!!!
*  p39 -  lab_pin  IS MISSING !!!!
*  X9 -  pfet_g5v0d10v5  IS MISSING !!!!
*  p40 -  lab_pin  IS MISSING !!!!
*  p41 -  lab_pin  IS MISSING !!!!
*  p42 -  lab_pin  IS MISSING !!!!
*  p43 -  lab_pin  IS MISSING !!!!
*  X10 -  nfet_g5v0d10v5  IS MISSING !!!!
*  p44 -  lab_pin  IS MISSING !!!!
*  p45 -  lab_pin  IS MISSING !!!!
*  p46 -  lab_pin  IS MISSING !!!!
*  p47 -  lab_pin  IS MISSING !!!!
*  X11 -  nfet_01v8  IS MISSING !!!!
*  p48 -  lab_pin  IS MISSING !!!!
*  p49 -  lab_pin  IS MISSING !!!!
*  p50 -  lab_pin  IS MISSING !!!!
*  p51 -  lab_pin  IS MISSING !!!!
*  X12 -  pfet_01v8_hvt  IS MISSING !!!!
*  p52 -  lab_pin  IS MISSING !!!!
*  p53 -  lab_pin  IS MISSING !!!!
*  p54 -  lab_pin  IS MISSING !!!!
*  p55 -  lab_pin  IS MISSING !!!!
*  X13 -  nfet_g5v0d10v5  IS MISSING !!!!
*  p56 -  lab_pin  IS MISSING !!!!
*  p57 -  lab_pin  IS MISSING !!!!
*  p58 -  lab_pin  IS MISSING !!!!
*  p59 -  lab_pin  IS MISSING !!!!
*  X14 -  nfet_g5v0d10v5  IS MISSING !!!!
*  p60 -  lab_pin  IS MISSING !!!!
*  p61 -  lab_pin  IS MISSING !!!!
*  p62 -  lab_pin  IS MISSING !!!!
*  p63 -  lab_pin  IS MISSING !!!!
*  X15 -  pfet_g5v0d10v5  IS MISSING !!!!
*  p64 -  lab_pin  IS MISSING !!!!
*  p65 -  lab_pin  IS MISSING !!!!
*  p66 -  lab_pin  IS MISSING !!!!
*  p67 -  lab_pin  IS MISSING !!!!
*  X16 -  nfet_g5v0d10v5  IS MISSING !!!!
*  p68 -  lab_pin  IS MISSING !!!!
*  p69 -  lab_pin  IS MISSING !!!!
*  p70 -  lab_pin  IS MISSING !!!!
*  p71 -  lab_pin  IS MISSING !!!!
*  X17 -  nfet_g5v0d10v5  IS MISSING !!!!
*  p72 -  lab_pin  IS MISSING !!!!
*  p73 -  lab_pin  IS MISSING !!!!
*  p74 -  lab_pin  IS MISSING !!!!
*  p75 -  lab_pin  IS MISSING !!!!
*  X18 -  nfet_g5v0d10v5  IS MISSING !!!!
*  p76 -  lab_pin  IS MISSING !!!!
*  p77 -  lab_pin  IS MISSING !!!!
*  p78 -  lab_pin  IS MISSING !!!!
*  p79 -  lab_pin  IS MISSING !!!!
*  X19 -  nfet_g5v0d10v5  IS MISSING !!!!
.ends
