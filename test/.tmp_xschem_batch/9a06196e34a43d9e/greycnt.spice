** sch_path: /nix/store/qriw4afhakn3sqg2al06kdyr745hx86w-xschem-3.4.7/share/doc/xschem/examples/greycnt.sch
.subckt greycnt

x2 B[4] A[5] A[4] xnor
x3 B[5] A[6] A[5] xnor
x14 B[6] A[7] A[6] xnor
v1 B[7] A[7] 0
x1 B[1] A[2] A[1] xnor
x4 B[2] A[3] A[2] xnor
x5 B[3] A[4] A[3] xnor
x6 B[0] A[1] A[0] xnor
x7 C[4] C[5] B[4] xnor
x8 C[5] C[6] B[5] xnor
x9 C[6] C[7] B[6] xnor
v0 C[7] B[7] 0
x10 C[1] C[2] B[1] xnor
x11 C[2] C[3] B[2] xnor
x12 C[3] C[4] B[3] xnor
x13 C[0] C[1] B[0] xnor
* noconn A[7:0]
* tap: C[7:0] --> C[0]
* tap: C[7:0] --> C[1]
* tap: C[7:0] --> C[2]
* tap: C[7:0] --> C[3]
* tap: C[7:0] --> C[4]
* tap: C[7:0] --> C[5]
* tap: C[7:0] --> C[6]
* tap: C[7:0] --> C[7]
* tap: A[7:0] --> A[0]
* tap: A[7:0] --> A[1]
* tap: A[7:0] --> A[2]
* tap: A[7:0] --> A[3]
* tap: A[7:0] --> A[4]
* tap: A[7:0] --> A[5]
* tap: A[7:0] --> A[6]
* tap: A[7:0] --> A[7]
**** begin user architecture code

* ngspice commands
.options save all
.control
  tran 1n 2000n
  remzerovec
  write greycnt.raw
.endc

* to generate following file copy .../share/doc/xschem/examples/stimuli.greycnt
* to the simulation directory and run simulation -> Utile Stimuli Editor (GUI),
* and press 'Translate'
.include stimuli_greycnt.cir

.model nmos nmos level=49 version=3.3.0 vth0=0.8
.model pmos pmos level=49 version=3.3.0 vth0=-0.8

**** end user architecture code
.ends

* expanding   symbol:  xnor.sym # of pins=3
** sym_path: /nix/store/qriw4afhakn3sqg2al06kdyr745hx86w-xschem-3.4.7/share/doc/xschem/examples/xnor.sym
** sch_path: /nix/store/qriw4afhakn3sqg2al06kdyr745hx86w-xschem-3.4.7/share/doc/xschem/examples/xnor.sch
.subckt xnor Z A B  risedel=400 falldel=300
*.PININFO B:I Z:O A:I
M1 net2 A GND GND nmos w=10u l=1u m=1
M2 net3 net1 GND GND nmos w=10u l=1u m=1
M3 Z A net3 GND nmos w=10u l=1u m=1
M4 Z B net3 GND nmos w=10u l=1u m=1
M5 net1 B net2 GND nmos w=10u l=1u m=1
M6 net1 A VDD VDD pmos w=10u l=1u m=1
M7 net1 B VDD VDD pmos w=10u l=1u m=1
M8 net4 A VDD VDD pmos w=10u l=1u m=1
M9 Z B net4 VDD pmos w=10u l=1u m=1
M10 Z net1 VDD VDD pmos w=10u l=1u m=1
.ends

.GLOBAL GND
.GLOBAL VDD
