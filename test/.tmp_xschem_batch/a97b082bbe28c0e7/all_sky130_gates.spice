** sch_path: /home/omare/Documents/UWASIC/Schemify/test/examples/xschem_sky130/sky130_tests/all_sky130_gates.sch
.subckt all_sky130_gates

*  x1 -  a2111o_1  IS MISSING !!!!
*  x2 -  a2111o_2  IS MISSING !!!!
*  x3 -  a2111o_4  IS MISSING !!!!
*  x4 -  a2111oi_0  IS MISSING !!!!
*  x5 -  a2111oi_1  IS MISSING !!!!
*  x6 -  a2111oi_2  IS MISSING !!!!
*  x7 -  a2111oi_4  IS MISSING !!!!
*  x8 -  a211o_1  IS MISSING !!!!
*  x9 -  a211o_2  IS MISSING !!!!
*  x10 -  a211o_4  IS MISSING !!!!
*  x11 -  a211oi_1  IS MISSING !!!!
*  x12 -  a211oi_2  IS MISSING !!!!
*  x13 -  a211oi_4  IS MISSING !!!!
*  x14 -  a21bo_1  IS MISSING !!!!
*  x15 -  a21bo_2  IS MISSING !!!!
*  x16 -  a21bo_4  IS MISSING !!!!
*  x17 -  a21boi_0  IS MISSING !!!!
*  x18 -  a21boi_1  IS MISSING !!!!
*  x19 -  a21boi_2  IS MISSING !!!!
*  x20 -  a21boi_4  IS MISSING !!!!
*  x21 -  a21o_1  IS MISSING !!!!
*  x22 -  a21o_2  IS MISSING !!!!
*  x23 -  a21o_4  IS MISSING !!!!
*  x24 -  a21oi_1  IS MISSING !!!!
*  x25 -  a21oi_2  IS MISSING !!!!
*  x26 -  a21oi_4  IS MISSING !!!!
*  x27 -  a221o_1  IS MISSING !!!!
*  x28 -  a221o_2  IS MISSING !!!!
*  x29 -  a221o_4  IS MISSING !!!!
*  x30 -  a221oi_1  IS MISSING !!!!
*  x31 -  a221oi_2  IS MISSING !!!!
*  x32 -  a221oi_4  IS MISSING !!!!
*  x33 -  a222oi_1  IS MISSING !!!!
*  x34 -  a22o_1  IS MISSING !!!!
*  x35 -  a22o_2  IS MISSING !!!!
*  x36 -  a22o_4  IS MISSING !!!!
*  x37 -  a22oi_1  IS MISSING !!!!
*  x38 -  a22oi_2  IS MISSING !!!!
*  x39 -  a22oi_4  IS MISSING !!!!
*  x40 -  a2bb2o_1  IS MISSING !!!!
*  x41 -  a2bb2o_2  IS MISSING !!!!
*  x42 -  a2bb2o_4  IS MISSING !!!!
*  x43 -  a2bb2oi_1  IS MISSING !!!!
*  x44 -  a2bb2oi_2  IS MISSING !!!!
*  x45 -  a2bb2oi_4  IS MISSING !!!!
*  x46 -  a311o_1  IS MISSING !!!!
*  x47 -  a311o_2  IS MISSING !!!!
*  x48 -  a311o_4  IS MISSING !!!!
*  x49 -  a311oi_1  IS MISSING !!!!
*  x50 -  a311oi_2  IS MISSING !!!!
*  x51 -  a311oi_4  IS MISSING !!!!
*  x52 -  a31o_1  IS MISSING !!!!
*  x53 -  a31o_2  IS MISSING !!!!
*  x54 -  a31o_4  IS MISSING !!!!
*  x55 -  a31oi_1  IS MISSING !!!!
*  x56 -  a31oi_2  IS MISSING !!!!
*  x57 -  a31oi_4  IS MISSING !!!!
*  x58 -  a32o_1  IS MISSING !!!!
*  x59 -  a32o_2  IS MISSING !!!!
*  x60 -  a32o_4  IS MISSING !!!!
*  x61 -  a32oi_1  IS MISSING !!!!
*  x62 -  a32oi_2  IS MISSING !!!!
*  x63 -  a32oi_4  IS MISSING !!!!
*  x64 -  a41o_1  IS MISSING !!!!
*  x65 -  a41o_2  IS MISSING !!!!
*  x66 -  a41o_4  IS MISSING !!!!
*  x67 -  a41oi_1  IS MISSING !!!!
*  x68 -  a41oi_2  IS MISSING !!!!
*  x69 -  a41oi_4  IS MISSING !!!!
*  x70 -  and2_0  IS MISSING !!!!
*  x71 -  and2_1  IS MISSING !!!!
*  x72 -  and2_2  IS MISSING !!!!
*  x73 -  and2_4  IS MISSING !!!!
*  x74 -  and2b_1  IS MISSING !!!!
*  x75 -  and2b_2  IS MISSING !!!!
*  x76 -  and2b_4  IS MISSING !!!!
*  x77 -  and3_1  IS MISSING !!!!
*  x78 -  and3_2  IS MISSING !!!!
*  x79 -  and3_4  IS MISSING !!!!
*  x80 -  and3b_1  IS MISSING !!!!
*  x81 -  and3b_2  IS MISSING !!!!
*  x82 -  and3b_4  IS MISSING !!!!
*  x83 -  and4_1  IS MISSING !!!!
*  x84 -  and4_2  IS MISSING !!!!
*  x85 -  and4_4  IS MISSING !!!!
*  x86 -  and4b_1  IS MISSING !!!!
*  x87 -  and4b_2  IS MISSING !!!!
*  x88 -  and4b_4  IS MISSING !!!!
*  x89 -  and4bb_1  IS MISSING !!!!
*  x90 -  and4bb_2  IS MISSING !!!!
*  x91 -  and4bb_4  IS MISSING !!!!
*  x92 -  buf_12  IS MISSING !!!!
*  x93 -  buf_16  IS MISSING !!!!
*  x94 -  buf_1  IS MISSING !!!!
*  x95 -  buf_2  IS MISSING !!!!
*  x96 -  buf_4  IS MISSING !!!!
*  x97 -  buf_6  IS MISSING !!!!
*  x98 -  buf_8  IS MISSING !!!!
*  x99 -  bufbuf_16  IS MISSING !!!!
*  x100 -  bufbuf_8  IS MISSING !!!!
*  x101 -  bufinv_16  IS MISSING !!!!
*  x102 -  bufinv_8  IS MISSING !!!!
*  x103 -  clkbuf_16  IS MISSING !!!!
*  x104 -  clkbuf_1  IS MISSING !!!!
*  x105 -  clkbuf_2  IS MISSING !!!!
*  x106 -  clkbuf_4  IS MISSING !!!!
*  x107 -  clkbuf_8  IS MISSING !!!!
*  x108 -  clkdlybuf4s15_1  IS MISSING !!!!
*  x109 -  clkdlybuf4s15_2  IS MISSING !!!!
*  x110 -  clkdlybuf4s18_1  IS MISSING !!!!
*  x111 -  clkdlybuf4s18_2  IS MISSING !!!!
*  x112 -  clkdlybuf4s25_1  IS MISSING !!!!
*  x113 -  clkdlybuf4s25_2  IS MISSING !!!!
*  x114 -  clkdlybuf4s50_1  IS MISSING !!!!
*  x115 -  clkdlybuf4s50_2  IS MISSING !!!!
*  x116 -  clkinv_16  IS MISSING !!!!
*  x117 -  clkinv_1  IS MISSING !!!!
*  x118 -  clkinv_2  IS MISSING !!!!
*  x119 -  clkinv_4  IS MISSING !!!!
*  x120 -  clkinv_8  IS MISSING !!!!
*  x121 -  clkinvlp_2  IS MISSING !!!!
*  x122 -  clkinvlp_4  IS MISSING !!!!
*  x123 -  conb_1  IS MISSING !!!!
*  x124 -  decap_12  IS MISSING !!!!
*  x125 -  decap_3  IS MISSING !!!!
*  x126 -  decap_4  IS MISSING !!!!
*  x127 -  decap_6  IS MISSING !!!!
*  x128 -  decap_8  IS MISSING !!!!
*  x129 -  dfbbn_1  IS MISSING !!!!
*  x130 -  dfbbn_2  IS MISSING !!!!
*  x131 -  dfbbp_1  IS MISSING !!!!
*  x132 -  dfrbp_1  IS MISSING !!!!
*  x133 -  dfrbp_2  IS MISSING !!!!
*  x134 -  dfrtn_1  IS MISSING !!!!
*  x135 -  dfrtp_1  IS MISSING !!!!
*  x136 -  dfrtp_2  IS MISSING !!!!
*  x137 -  dfrtp_4  IS MISSING !!!!
*  x138 -  dfsbp_1  IS MISSING !!!!
*  x139 -  dfsbp_2  IS MISSING !!!!
*  x140 -  dfstp_1  IS MISSING !!!!
*  x141 -  dfstp_2  IS MISSING !!!!
*  x142 -  dfstp_4  IS MISSING !!!!
*  x143 -  dfxbp_1  IS MISSING !!!!
*  x144 -  dfxbp_2  IS MISSING !!!!
*  x145 -  dfxtp_1  IS MISSING !!!!
*  x146 -  dfxtp_2  IS MISSING !!!!
*  x147 -  dfxtp_4  IS MISSING !!!!
*  x148 -  diode_2  IS MISSING !!!!
*  x149 -  dlclkp_1  IS MISSING !!!!
*  x150 -  dlclkp_2  IS MISSING !!!!
*  x151 -  dlclkp_4  IS MISSING !!!!
*  x152 -  dlrbn_1  IS MISSING !!!!
*  x153 -  dlrbn_2  IS MISSING !!!!
*  x154 -  dlrbp_1  IS MISSING !!!!
*  x155 -  dlrbp_2  IS MISSING !!!!
*  x156 -  dlrtn_1  IS MISSING !!!!
*  x157 -  dlrtn_2  IS MISSING !!!!
*  x158 -  dlrtn_4  IS MISSING !!!!
*  x159 -  dlrtp_1  IS MISSING !!!!
*  x160 -  dlrtp_2  IS MISSING !!!!
*  x161 -  dlrtp_4  IS MISSING !!!!
*  x162 -  dlxbn_1  IS MISSING !!!!
*  x163 -  dlxbn_2  IS MISSING !!!!
*  x164 -  dlxbp_1  IS MISSING !!!!
*  x165 -  dlxtn_1  IS MISSING !!!!
*  x166 -  dlxtn_2  IS MISSING !!!!
*  x167 -  dlxtn_4  IS MISSING !!!!
*  x168 -  dlxtp_1  IS MISSING !!!!
*  x169 -  dlygate4sd1_1  IS MISSING !!!!
*  x170 -  dlygate4sd2_1  IS MISSING !!!!
*  x171 -  dlygate4sd3_1  IS MISSING !!!!
*  x172 -  dlymetal6s2s_1  IS MISSING !!!!
*  x173 -  dlymetal6s4s_1  IS MISSING !!!!
*  x174 -  dlymetal6s6s_1  IS MISSING !!!!
*  x175 -  ebufn_1  IS MISSING !!!!
*  x176 -  ebufn_2  IS MISSING !!!!
*  x177 -  ebufn_4  IS MISSING !!!!
*  x178 -  ebufn_8  IS MISSING !!!!
*  x179 -  edfxbp_1  IS MISSING !!!!
*  x180 -  edfxtp_1  IS MISSING !!!!
*  x181 -  einvn_0  IS MISSING !!!!
*  x182 -  einvn_1  IS MISSING !!!!
*  x183 -  einvn_2  IS MISSING !!!!
*  x184 -  einvn_4  IS MISSING !!!!
*  x185 -  einvn_8  IS MISSING !!!!
*  x186 -  einvp_1  IS MISSING !!!!
*  x187 -  einvp_2  IS MISSING !!!!
*  x188 -  einvp_4  IS MISSING !!!!
*  x189 -  einvp_8  IS MISSING !!!!
*  x190 -  fa_1  IS MISSING !!!!
*  x191 -  fa_2  IS MISSING !!!!
*  x192 -  fa_4  IS MISSING !!!!
*  x193 -  fah_1  IS MISSING !!!!
*  x194 -  fahcin_1  IS MISSING !!!!
*  x195 -  fahcon_1  IS MISSING !!!!
*  x196 -  fill_1  IS MISSING !!!!
*  x197 -  fill_2  IS MISSING !!!!
*  x198 -  fill_4  IS MISSING !!!!
*  x199 -  fill_8  IS MISSING !!!!
*  x200 -  ha_1  IS MISSING !!!!
*  x201 -  ha_2  IS MISSING !!!!
*  x202 -  ha_4  IS MISSING !!!!
*  x203 -  inv_12  IS MISSING !!!!
*  x204 -  inv_16  IS MISSING !!!!
*  x205 -  inv_1  IS MISSING !!!!
*  x206 -  inv_2  IS MISSING !!!!
*  x207 -  inv_4  IS MISSING !!!!
*  x208 -  inv_6  IS MISSING !!!!
*  x209 -  inv_8  IS MISSING !!!!
*  x210 -  lpflow_bleeder_1  IS MISSING !!!!
*  x211 -  lpflow_clkbufkapwr_16  IS MISSING !!!!
*  x212 -  lpflow_clkbufkapwr_1  IS MISSING !!!!
*  x213 -  lpflow_clkbufkapwr_2  IS MISSING !!!!
*  x214 -  lpflow_clkbufkapwr_4  IS MISSING !!!!
*  x215 -  lpflow_clkbufkapwr_8  IS MISSING !!!!
*  x216 -  lpflow_clkinvkapwr_16  IS MISSING !!!!
*  x217 -  lpflow_clkinvkapwr_1  IS MISSING !!!!
*  x218 -  lpflow_clkinvkapwr_2  IS MISSING !!!!
*  x219 -  lpflow_clkinvkapwr_4  IS MISSING !!!!
*  x220 -  lpflow_clkinvkapwr_8  IS MISSING !!!!
*  x221 -  lpflow_decapkapwr_12  IS MISSING !!!!
*  x222 -  lpflow_decapkapwr_3  IS MISSING !!!!
*  x223 -  lpflow_decapkapwr_4  IS MISSING !!!!
*  x224 -  lpflow_decapkapwr_6  IS MISSING !!!!
*  x225 -  lpflow_decapkapwr_8  IS MISSING !!!!
*  x226 -  lpflow_inputiso0n_1  IS MISSING !!!!
*  x227 -  lpflow_inputiso0p_1  IS MISSING !!!!
*  x228 -  lpflow_inputiso1n_1  IS MISSING !!!!
*  x229 -  lpflow_inputiso1p_1  IS MISSING !!!!
*  x230 -  lpflow_inputisolatch_1  IS MISSING !!!!
*  x231 -  lpflow_isobufsrc_16  IS MISSING !!!!
*  x232 -  lpflow_isobufsrc_1  IS MISSING !!!!
*  x233 -  lpflow_isobufsrc_2  IS MISSING !!!!
*  x234 -  lpflow_isobufsrc_4  IS MISSING !!!!
*  x235 -  lpflow_isobufsrc_8  IS MISSING !!!!
*  x236 -  lpflow_isobufsrckapwr_16  IS MISSING !!!!
*  x237 -  lpflow_lsbuf_lh_hl_isowell_tap_1  IS MISSING !!!!
*  x238 -  lpflow_lsbuf_lh_hl_isowell_tap_2  IS MISSING !!!!
*  x239 -  lpflow_lsbuf_lh_hl_isowell_tap_4  IS MISSING !!!!
*  x240 -  lpflow_lsbuf_lh_isowell_4  IS MISSING !!!!
*  x241 -  lpflow_lsbuf_lh_isowell_tap_1  IS MISSING !!!!
*  x242 -  lpflow_lsbuf_lh_isowell_tap_2  IS MISSING !!!!
*  x243 -  lpflow_lsbuf_lh_isowell_tap_4  IS MISSING !!!!
*  x244 -  macro_sparecell  IS MISSING !!!!
*  x245 -  maj3_1  IS MISSING !!!!
*  x246 -  maj3_2  IS MISSING !!!!
*  x247 -  maj3_4  IS MISSING !!!!
*  x248 -  mux2_1  IS MISSING !!!!
*  x249 -  mux2_2  IS MISSING !!!!
*  x250 -  mux2_4  IS MISSING !!!!
*  x251 -  mux2_8  IS MISSING !!!!
*  x252 -  mux2i_1  IS MISSING !!!!
*  x253 -  mux2i_2  IS MISSING !!!!
*  x254 -  mux2i_4  IS MISSING !!!!
*  x255 -  mux4_1  IS MISSING !!!!
*  x256 -  mux4_2  IS MISSING !!!!
*  x257 -  mux4_4  IS MISSING !!!!
*  x258 -  nand2_1  IS MISSING !!!!
*  x259 -  nand2_2  IS MISSING !!!!
*  x260 -  nand2_4  IS MISSING !!!!
*  x261 -  nand2_8  IS MISSING !!!!
*  x262 -  nand2b_1  IS MISSING !!!!
*  x263 -  nand2b_2  IS MISSING !!!!
*  x264 -  nand2b_4  IS MISSING !!!!
*  x265 -  nand3_1  IS MISSING !!!!
*  x266 -  nand3_2  IS MISSING !!!!
*  x267 -  nand3_4  IS MISSING !!!!
*  x268 -  nand3b_1  IS MISSING !!!!
*  x269 -  nand3b_2  IS MISSING !!!!
*  x270 -  nand3b_4  IS MISSING !!!!
*  x271 -  nand4_1  IS MISSING !!!!
*  x272 -  nand4_2  IS MISSING !!!!
*  x273 -  nand4_4  IS MISSING !!!!
*  x274 -  nand4b_1  IS MISSING !!!!
*  x275 -  nand4b_2  IS MISSING !!!!
*  x276 -  nand4b_4  IS MISSING !!!!
*  x277 -  nand4bb_1  IS MISSING !!!!
*  x278 -  nand4bb_2  IS MISSING !!!!
*  x279 -  nand4bb_4  IS MISSING !!!!
*  x280 -  nor2_1  IS MISSING !!!!
*  x281 -  nor2_2  IS MISSING !!!!
*  x282 -  nor2_4  IS MISSING !!!!
*  x283 -  nor2_8  IS MISSING !!!!
*  x284 -  nor2b_1  IS MISSING !!!!
*  x285 -  nor2b_2  IS MISSING !!!!
*  x286 -  nor2b_4  IS MISSING !!!!
*  x287 -  nor3_1  IS MISSING !!!!
*  x288 -  nor3_2  IS MISSING !!!!
*  x289 -  nor3_4  IS MISSING !!!!
*  x290 -  nor3b_1  IS MISSING !!!!
*  x291 -  nor3b_2  IS MISSING !!!!
*  x292 -  nor3b_4  IS MISSING !!!!
*  x293 -  nor4_1  IS MISSING !!!!
*  x294 -  nor4_2  IS MISSING !!!!
*  x295 -  nor4_4  IS MISSING !!!!
*  x296 -  nor4b_1  IS MISSING !!!!
*  x297 -  nor4b_2  IS MISSING !!!!
*  x298 -  nor4b_4  IS MISSING !!!!
*  x299 -  nor4bb_1  IS MISSING !!!!
*  x300 -  nor4bb_2  IS MISSING !!!!
*  x301 -  nor4bb_4  IS MISSING !!!!
*  x302 -  o2111a_1  IS MISSING !!!!
*  x303 -  o2111a_2  IS MISSING !!!!
*  x304 -  o2111a_4  IS MISSING !!!!
*  x305 -  o2111ai_1  IS MISSING !!!!
*  x306 -  o2111ai_2  IS MISSING !!!!
*  x307 -  o2111ai_4  IS MISSING !!!!
*  x308 -  o211a_1  IS MISSING !!!!
*  x309 -  o211a_2  IS MISSING !!!!
*  x310 -  o211a_4  IS MISSING !!!!
*  x311 -  o211ai_1  IS MISSING !!!!
*  x312 -  o211ai_2  IS MISSING !!!!
*  x313 -  o211ai_4  IS MISSING !!!!
*  x314 -  o21a_1  IS MISSING !!!!
*  x315 -  o21a_2  IS MISSING !!!!
*  x316 -  o21a_4  IS MISSING !!!!
*  x317 -  o21ai_0  IS MISSING !!!!
*  x318 -  o21ai_1  IS MISSING !!!!
*  x319 -  o21ai_2  IS MISSING !!!!
*  x320 -  o21ai_4  IS MISSING !!!!
*  x321 -  o21ba_1  IS MISSING !!!!
*  x322 -  o21ba_2  IS MISSING !!!!
*  x323 -  o21ba_4  IS MISSING !!!!
*  x324 -  o21bai_1  IS MISSING !!!!
*  x325 -  o21bai_2  IS MISSING !!!!
*  x326 -  o21bai_4  IS MISSING !!!!
*  x327 -  o221a_1  IS MISSING !!!!
*  x328 -  o221a_2  IS MISSING !!!!
*  x329 -  o221a_4  IS MISSING !!!!
*  x330 -  o221ai_1  IS MISSING !!!!
*  x331 -  o221ai_2  IS MISSING !!!!
*  x332 -  o221ai_4  IS MISSING !!!!
*  x333 -  o22a_1  IS MISSING !!!!
*  x334 -  o22a_2  IS MISSING !!!!
*  x335 -  o22a_4  IS MISSING !!!!
*  x336 -  o22ai_1  IS MISSING !!!!
*  x337 -  o22ai_2  IS MISSING !!!!
*  x338 -  o22ai_4  IS MISSING !!!!
*  x339 -  o2bb2a_1  IS MISSING !!!!
*  x340 -  o2bb2a_2  IS MISSING !!!!
*  x341 -  o2bb2a_4  IS MISSING !!!!
*  x342 -  o2bb2ai_1  IS MISSING !!!!
*  x343 -  o2bb2ai_2  IS MISSING !!!!
*  x344 -  o2bb2ai_4  IS MISSING !!!!
*  x345 -  o311a_1  IS MISSING !!!!
*  x346 -  o311a_2  IS MISSING !!!!
*  x347 -  o311a_4  IS MISSING !!!!
*  x348 -  o311ai_0  IS MISSING !!!!
*  x349 -  o311ai_1  IS MISSING !!!!
*  x350 -  o311ai_2  IS MISSING !!!!
*  x351 -  o311ai_4  IS MISSING !!!!
*  x352 -  o31a_1  IS MISSING !!!!
*  x353 -  o31a_2  IS MISSING !!!!
*  x354 -  o31a_4  IS MISSING !!!!
*  x355 -  o31ai_1  IS MISSING !!!!
*  x356 -  o31ai_2  IS MISSING !!!!
*  x357 -  o31ai_4  IS MISSING !!!!
*  x358 -  o32a_1  IS MISSING !!!!
*  x359 -  o32a_2  IS MISSING !!!!
*  x360 -  o32a_4  IS MISSING !!!!
*  x361 -  o32ai_1  IS MISSING !!!!
*  x362 -  o32ai_2  IS MISSING !!!!
*  x363 -  o32ai_4  IS MISSING !!!!
*  x364 -  o41a_1  IS MISSING !!!!
*  x365 -  o41a_2  IS MISSING !!!!
*  x366 -  o41a_4  IS MISSING !!!!
*  x367 -  o41ai_1  IS MISSING !!!!
*  x368 -  o41ai_2  IS MISSING !!!!
*  x369 -  o41ai_4  IS MISSING !!!!
*  x370 -  or2_0  IS MISSING !!!!
*  x371 -  or2_1  IS MISSING !!!!
*  x372 -  or2_2  IS MISSING !!!!
*  x373 -  or2_4  IS MISSING !!!!
*  x374 -  or2b_1  IS MISSING !!!!
*  x375 -  or2b_2  IS MISSING !!!!
*  x376 -  or2b_4  IS MISSING !!!!
*  x377 -  or3_1  IS MISSING !!!!
*  x378 -  or3_2  IS MISSING !!!!
*  x379 -  or3_4  IS MISSING !!!!
*  x380 -  or3b_1  IS MISSING !!!!
*  x381 -  or3b_2  IS MISSING !!!!
*  x382 -  or3b_4  IS MISSING !!!!
*  x383 -  or4_1  IS MISSING !!!!
*  x384 -  or4_2  IS MISSING !!!!
*  x385 -  or4_4  IS MISSING !!!!
*  x386 -  or4b_1  IS MISSING !!!!
*  x387 -  or4b_2  IS MISSING !!!!
*  x388 -  or4b_4  IS MISSING !!!!
*  x389 -  or4bb_1  IS MISSING !!!!
*  x390 -  or4bb_2  IS MISSING !!!!
*  x391 -  or4bb_4  IS MISSING !!!!
*  x392 -  probec_p_8  IS MISSING !!!!
*  x393 -  probe_p_8  IS MISSING !!!!
*  x394 -  sdfbbn_1  IS MISSING !!!!
*  x395 -  sdfbbn_2  IS MISSING !!!!
*  x396 -  sdfbbp_1  IS MISSING !!!!
*  x397 -  sdfrbp_1  IS MISSING !!!!
*  x398 -  sdfrbp_2  IS MISSING !!!!
*  x399 -  sdfrtn_1  IS MISSING !!!!
*  x400 -  sdfrtp_1  IS MISSING !!!!
*  x401 -  sdfrtp_2  IS MISSING !!!!
*  x402 -  sdfrtp_4  IS MISSING !!!!
*  x403 -  sdfsbp_1  IS MISSING !!!!
*  x404 -  sdfsbp_2  IS MISSING !!!!
*  x405 -  sdfstp_1  IS MISSING !!!!
*  x406 -  sdfstp_2  IS MISSING !!!!
*  x407 -  sdfstp_4  IS MISSING !!!!
*  x408 -  sdfxbp_1  IS MISSING !!!!
*  x409 -  sdfxbp_2  IS MISSING !!!!
*  x410 -  sdfxtp_1  IS MISSING !!!!
*  x411 -  sdfxtp_2  IS MISSING !!!!
*  x412 -  sdfxtp_4  IS MISSING !!!!
*  x413 -  sdlclkp_1  IS MISSING !!!!
*  x414 -  sdlclkp_2  IS MISSING !!!!
*  x415 -  sdlclkp_4  IS MISSING !!!!
*  x416 -  sedfxbp_1  IS MISSING !!!!
*  x417 -  sedfxbp_2  IS MISSING !!!!
*  x418 -  sedfxtp_1  IS MISSING !!!!
*  x419 -  sedfxtp_2  IS MISSING !!!!
*  x420 -  sedfxtp_4  IS MISSING !!!!
*  x421 -  tap_1  IS MISSING !!!!
*  x422 -  tap_2  IS MISSING !!!!
*  x423 -  tapvgnd_1  IS MISSING !!!!
*  x424 -  tapvgnd2_1  IS MISSING !!!!
*  x425 -  tapvpwrvgnd_1  IS MISSING !!!!
*  x426 -  xnor2_1  IS MISSING !!!!
*  x427 -  xnor2_2  IS MISSING !!!!
*  x428 -  xnor2_4  IS MISSING !!!!
*  x429 -  xnor3_1  IS MISSING !!!!
*  x430 -  xnor3_2  IS MISSING !!!!
*  x431 -  xnor3_4  IS MISSING !!!!
*  x432 -  xor2_1  IS MISSING !!!!
*  x433 -  xor2_2  IS MISSING !!!!
*  x434 -  xor2_4  IS MISSING !!!!
*  x435 -  xor3_1  IS MISSING !!!!
*  x436 -  xor3_2  IS MISSING !!!!
*  x437 -  xor3_4  IS MISSING !!!!
*  l1 -  title  IS MISSING !!!!
.ends
