** sch_path: /nix/store/qriw4afhakn3sqg2al06kdyr745hx86w-xschem-3.4.7/share/doc/xschem/ngspice/diode_ngspice.sch
.subckt diode_ngspice plus minus
*.PININFO plus:B minus:B
Vm mn minus 0
.save i(vm)
Vp plus pn 0
.save i(vp)
B1 pn mn I = 'v(pn,mn) > 0 ? v(pn,mn) / Ron : v(pn,mn) / Roff' m=1
.ends
