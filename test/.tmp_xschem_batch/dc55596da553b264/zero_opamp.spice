** sch_path: /home/omare/Documents/UWASIC/Schemify/test/examples/xschem_sky130/sky130_tests/zero_opamp.sch
.subckt zero_opamp EN_N MINUS PLUS DIFFOUT VCC VSS ADJ

*  l1 -  title  IS MISSING !!!!
*  p93 -  ipin  IS MISSING !!!!
*  p94 -  ipin  IS MISSING !!!!
*  p95 -  ipin  IS MISSING !!!!
*  p96 -  ipin  IS MISSING !!!!
*  p97 -  ipin  IS MISSING !!!!
*  p116 -  opin  IS MISSING !!!!
*  p20 -  lab_pin  IS MISSING !!!!
*  p21 -  lab_pin  IS MISSING !!!!
*  p22 -  lab_pin  IS MISSING !!!!
*  p23 -  lab_pin  IS MISSING !!!!
*  p24 -  lab_pin  IS MISSING !!!!
*  p25 -  lab_pin  IS MISSING !!!!
*  p26 -  lab_pin  IS MISSING !!!!
*  l9 -  lab_pin  IS MISSING !!!!
*  l11 -  lab_pin  IS MISSING !!!!
*  l12 -  lab_pin  IS MISSING !!!!
*  C6 -  parax_cap  IS MISSING !!!!
*  l14 -  lab_pin  IS MISSING !!!!
*  M4 -  pfet_01v8  IS MISSING !!!!
*  M18 -  nfet_01v8_lvt  IS MISSING !!!!
*  M2 -  nfet_01v8_lvt  IS MISSING !!!!
*  MR -  pfet_01v8_lvt  IS MISSING !!!!
*  ML -  pfet_01v8_lvt  IS MISSING !!!!
*  l3 -  lab_pin  IS MISSING !!!!
*  v1 -  ammeter  IS MISSING !!!!
*  C4 -  parax_cap  IS MISSING !!!!
*  C1 -  parax_cap  IS MISSING !!!!
*  p2 -  lab_pin  IS MISSING !!!!
*  l10 -  lab_pin  IS MISSING !!!!
*  C5 -  parax_cap  IS MISSING !!!!
*  M6 -  nfet_01v8_lvt  IS MISSING !!!!
*  v2 -  ammeter  IS MISSING !!!!
*  v4 -  ammeter  IS MISSING !!!!
*  v6 -  ammeter  IS MISSING !!!!
*  l5 -  lab_pin  IS MISSING !!!!
*  p5 -  lab_pin  IS MISSING !!!!
*  M7 -  nfet_01v8  IS MISSING !!!!
*  l6 -  lab_pin  IS MISSING !!!!
*  p12 -  ipin  IS MISSING !!!!
*  l4 -  lab_pin  IS MISSING !!!!
*  p123 -  lab_pin  IS MISSING !!!!
*  p124 -  lab_pin  IS MISSING !!!!
*  l65 -  lab_pin  IS MISSING !!!!
*  M46 -  pfet_01v8  IS MISSING !!!!
*  v17 -  ammeter  IS MISSING !!!!
*  p141 -  lab_pin  IS MISSING !!!!
*  M12 -  nfet_01v8_lvt  IS MISSING !!!!
*  l71 -  lab_pin  IS MISSING !!!!
*  p142 -  lab_pin  IS MISSING !!!!
*  M54 -  pfet_01v8_lvt  IS MISSING !!!!
*  p143 -  lab_pin  IS MISSING !!!!
*  p144 -  lab_pin  IS MISSING !!!!
*  M5 -  pfet_01v8_lvt  IS MISSING !!!!
*  p6 -  lab_pin  IS MISSING !!!!
*  p7 -  lab_pin  IS MISSING !!!!
*  l7 -  lab_pin  IS MISSING !!!!
*  p8 -  lab_pin  IS MISSING !!!!
*  M8 -  pfet_01v8_lvt  IS MISSING !!!!
*  p9 -  lab_pin  IS MISSING !!!!
*  M9 -  nfet_01v8  IS MISSING !!!!
*  p10 -  lab_pin  IS MISSING !!!!
*  M10 -  nfet_01v8  IS MISSING !!!!
*  l8 -  lab_pin  IS MISSING !!!!
*  p11 -  lab_pin  IS MISSING !!!!
*  p27 -  lab_pin  IS MISSING !!!!
*  M1 -  pfet_01v8  IS MISSING !!!!
*  v3 -  ammeter  IS MISSING !!!!
*  v5 -  ammeter  IS MISSING !!!!
*  v7 -  ammeter  IS MISSING !!!!
.ends
