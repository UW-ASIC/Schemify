** sch_path: /home/omare/Documents/UWASIC/Schemify/test/examples/xschem_sky130/sky130_tests/tb_bandgap.sch
.subckt tb_bandgap

*  NGSPICE -  code  IS MISSING !!!!
*  l1 -  title  IS MISSING !!!!
*  x1 -  bandgap  IS MISSING !!!!
*  p1 -  lab_pin  IS MISSING !!!!
*  p2 -  lab_pin  IS MISSING !!!!
*  V1 -  vsource  IS MISSING !!!!
*  p3 -  lab_pin  IS MISSING !!!!
*  V2 -  vsource  IS MISSING !!!!
*  l29 -  lab_pin  IS MISSING !!!!
*  p4 -  lab_pin  IS MISSING !!!!
*  p5 -  lab_pin  IS MISSING !!!!
*  V3 -  vsource  IS MISSING !!!!
*  l3 -  lab_pin  IS MISSING !!!!
*  l2 -  lab_pin  IS MISSING !!!!
*  l4 -  lab_pin  IS MISSING !!!!
*  l5 -  lab_pin  IS MISSING !!!!
*  h2 -  launcher  IS MISSING !!!!
*  E5 -  vsource_arith  IS MISSING !!!!
*  p113 -  lab_pin  IS MISSING !!!!
*  p114 -  lab_pin  IS MISSING !!!!
*  V4 -  vsource  IS MISSING !!!!
*  p7 -  lab_pin  IS MISSING !!!!
*  l21 -  lab_pin  IS MISSING !!!!
*  V5 -  vsource  IS MISSING !!!!
*  l6 -  lab_pin  IS MISSING !!!!
*  p6 -  lab_pin  IS MISSING !!!!
*  p8 -  lab_pin  IS MISSING !!!!
*  p9 -  lab_pin  IS MISSING !!!!
*  h1 -  launcher  IS MISSING !!!!
*  CORNER -  corner  IS MISSING !!!!
*  p10 -  spice_probe  IS MISSING !!!!
*  p11 -  spice_probe  IS MISSING !!!!
*  p12 -  spice_probe  IS MISSING !!!!
*  p13 -  spice_probe  IS MISSING !!!!
*  p14 -  spice_probe  IS MISSING !!!!
*  p15 -  spice_probe  IS MISSING !!!!
*  p16 -  spice_probe  IS MISSING !!!!
*  VCC -  ammeter  IS MISSING !!!!
.ends
