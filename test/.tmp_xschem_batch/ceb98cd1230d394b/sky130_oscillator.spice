** sch_path: /home/omare/Documents/UWASIC/Schemify/test/examples/xschem_sky130/sky130_tests/sky130_oscillator.sch
.subckt sky130_oscillator

*  x9 -  lvnand  IS MISSING !!!!
*  x1 -  lvnand  IS MISSING !!!!
*  M1 -  pfet_01v8  IS MISSING !!!!
*  l1 -  vdd  IS MISSING !!!!
*  l2 -  gnd  IS MISSING !!!!
*  M2 -  nfet_01v8  IS MISSING !!!!
*  x2 -  not  IS MISSING !!!!
*  x3 -  not  IS MISSING !!!!
*  x4 -  lvnand  IS MISSING !!!!
*  x5 -  lvnand  IS MISSING !!!!
*  M3 -  pfet_01v8  IS MISSING !!!!
*  l3 -  vdd  IS MISSING !!!!
*  l4 -  gnd  IS MISSING !!!!
*  M4 -  nfet_01v8  IS MISSING !!!!
*  p1 -  lab_pin  IS MISSING !!!!
*  p2 -  lab_pin  IS MISSING !!!!
*  p3 -  lab_pin  IS MISSING !!!!
*  p4 -  lab_pin  IS MISSING !!!!
*  p5 -  lab_pin  IS MISSING !!!!
*  p6 -  lab_pin  IS MISSING !!!!
*  NGSPICE -  code  IS MISSING !!!!
*  CORNER -  corner  IS MISSING !!!!
*  l5 -  title  IS MISSING !!!!
*  h5 -  launcher  IS MISSING !!!!
*  p7 -  iopin  IS MISSING !!!!
*  p8 -  iopin  IS MISSING !!!!
*  p9 -  ipin  IS MISSING !!!!
*  p10 -  lab_wire  IS MISSING !!!!
*  p11 -  lab_wire  IS MISSING !!!!
*  p12 -  opin  IS MISSING !!!!
*  p13 -  opin  IS MISSING !!!!
*  p14 -  lab_wire  IS MISSING !!!!
*  p15 -  lab_wire  IS MISSING !!!!
*  p16 -  lab_wire  IS MISSING !!!!
*  p17 -  lab_wire  IS MISSING !!!!
*  p18 -  lab_pin  IS MISSING !!!!
*  p19 -  lab_pin  IS MISSING !!!!
*  x6 -  not  IS MISSING !!!!
*  x7 -  not  IS MISSING !!!!
*  p20 -  lab_pin  IS MISSING !!!!
*  p21 -  lab_pin  IS MISSING !!!!
*  p22 -  lab_pin  IS MISSING !!!!
*  p23 -  lab_pin  IS MISSING !!!!
*  C2 -  cap_mim_m3_2  IS MISSING !!!!
*  C1 -  cap_mim_m3_2  IS MISSING !!!!
*  R1 -  res_xhigh_po_1p41  IS MISSING !!!!
*  l6 -  gnd  IS MISSING !!!!
*  R2 -  res_xhigh_po_1p41  IS MISSING !!!!
*  l7 -  gnd  IS MISSING !!!!
*  VB -  ammeter  IS MISSING !!!!
*  VA -  ammeter  IS MISSING !!!!
*  h1 -  launcher  IS MISSING !!!!
.ends
