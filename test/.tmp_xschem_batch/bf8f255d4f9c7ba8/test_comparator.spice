** sch_path: /home/omare/Documents/UWASIC/Schemify/test/examples/xschem_sky130/sky130_tests/test_comparator.sch
.subckt test_comparator

*  h1 -  launcher  IS MISSING !!!!
*  h4 -  launcher  IS MISSING !!!!
*  l1 -  title  IS MISSING !!!!
*  p92 -  ipin  IS MISSING !!!!
*  p93 -  ipin  IS MISSING !!!!
*  p94 -  ipin  IS MISSING !!!!
*  p95 -  ipin  IS MISSING !!!!
*  p96 -  ipin  IS MISSING !!!!
*  p97 -  ipin  IS MISSING !!!!
*  p116 -  opin  IS MISSING !!!!
*  p126 -  lab_pin  IS MISSING !!!!
*  l50 -  lab_pin  IS MISSING !!!!
*  p15 -  lab_pin  IS MISSING !!!!
*  l4 -  lab_pin  IS MISSING !!!!
*  p283 -  lab_pin  IS MISSING !!!!
*  l56 -  lab_pin  IS MISSING !!!!
*  p284 -  lab_pin  IS MISSING !!!!
*  p199 -  lab_pin  IS MISSING !!!!
*  C38 -  parax_cap  IS MISSING !!!!
*  l19 -  lab_pin  IS MISSING !!!!
*  l44 -  lab_pin  IS MISSING !!!!
*  p179 -  lab_pin  IS MISSING !!!!
*  p180 -  lab_pin  IS MISSING !!!!
*  p181 -  lab_pin  IS MISSING !!!!
*  p182 -  lab_pin  IS MISSING !!!!
*  l45 -  lab_pin  IS MISSING !!!!
*  l46 -  lab_pin  IS MISSING !!!!
*  p183 -  lab_pin  IS MISSING !!!!
*  p184 -  lab_pin  IS MISSING !!!!
*  p185 -  lab_pin  IS MISSING !!!!
*  p186 -  lab_pin  IS MISSING !!!!
*  l47 -  lab_pin  IS MISSING !!!!
*  l48 -  lab_pin  IS MISSING !!!!
*  p189 -  lab_pin  IS MISSING !!!!
*  p190 -  lab_pin  IS MISSING !!!!
*  p191 -  lab_pin  IS MISSING !!!!
*  p192 -  lab_pin  IS MISSING !!!!
*  p193 -  lab_pin  IS MISSING !!!!
*  p194 -  lab_pin  IS MISSING !!!!
*  p195 -  lab_pin  IS MISSING !!!!
*  p196 -  lab_pin  IS MISSING !!!!
*  p197 -  lab_pin  IS MISSING !!!!
*  l49 -  lab_pin  IS MISSING !!!!
*  C3 -  parax_cap  IS MISSING !!!!
*  l51 -  lab_pin  IS MISSING !!!!
*  l52 -  lab_pin  IS MISSING !!!!
*  l53 -  lab_pin  IS MISSING !!!!
*  C30 -  parax_cap  IS MISSING !!!!
*  C1 -  parax_cap  IS MISSING !!!!
*  p198 -  lab_pin  IS MISSING !!!!
*  l54 -  lab_pin  IS MISSING !!!!
*  l55 -  lab_pin  IS MISSING !!!!
*  vndiff -  ammeter  IS MISSING !!!!
*  v3 -  ammeter  IS MISSING !!!!
*  v4 -  ammeter  IS MISSING !!!!
*  v6 -  ammeter  IS MISSING !!!!
*  p9 -  lab_pin  IS MISSING !!!!
*  p10 -  lab_pin  IS MISSING !!!!
*  p11 -  lab_pin  IS MISSING !!!!
*  p12 -  lab_pin  IS MISSING !!!!
*  C13 -  parax_cap  IS MISSING !!!!
*  v1 -  ammeter  IS MISSING !!!!
*  l3 -  lab_pin  IS MISSING !!!!
*  l5 -  lab_pin  IS MISSING !!!!
*  l6 -  lab_pin  IS MISSING !!!!
*  p13 -  lab_pin  IS MISSING !!!!
*  p14 -  lab_pin  IS MISSING !!!!
*  p16 -  lab_pin  IS MISSING !!!!
*  p17 -  lab_pin  IS MISSING !!!!
*  l8 -  lab_pin  IS MISSING !!!!
*  v5 -  ammeter  IS MISSING !!!!
*  p18 -  lab_pin  IS MISSING !!!!
*  p19 -  lab_pin  IS MISSING !!!!
*  l2 -  lab_pin  IS MISSING !!!!
*  l21 -  lab_wire  IS MISSING !!!!
*  p22 -  lab_pin  IS MISSING !!!!
*  p23 -  lab_pin  IS MISSING !!!!
*  p24 -  lab_pin  IS MISSING !!!!
*  p25 -  lab_pin  IS MISSING !!!!
*  p26 -  lab_pin  IS MISSING !!!!
*  l7 -  lab_pin  IS MISSING !!!!
*  l9 -  lab_pin  IS MISSING !!!!
*  l10 -  lab_pin  IS MISSING !!!!
*  l11 -  lab_pin  IS MISSING !!!!
*  C7 -  parax_cap  IS MISSING !!!!
*  l13 -  lab_pin  IS MISSING !!!!
*  x4 -  not  IS MISSING !!!!
*  x5 -  not  IS MISSING !!!!
*  M4 -  pfet_01v8  IS MISSING !!!!
*  M5 -  pfet_01v8_lvt  IS MISSING !!!!
*  M6 -  pfet_01v8_lvt  IS MISSING !!!!
*  M8 -  pfet_01v8_lvt  IS MISSING !!!!
*  M9 -  pfet_01v8_lvt  IS MISSING !!!!
*  M11 -  pfet_01v8  IS MISSING !!!!
*  M1 -  nfet_01v8  IS MISSING !!!!
*  M15 -  nfet_01v8_lvt  IS MISSING !!!!
*  M10 -  nfet_01v8_lvt  IS MISSING !!!!
*  M17 -  nfet_01v8_lvt  IS MISSING !!!!
*  M18 -  nfet_01v8_lvt  IS MISSING !!!!
*  M19 -  nfet_01v8_lvt  IS MISSING !!!!
*  M20 -  pfet_01v8_lvt  IS MISSING !!!!
*  M21 -  pfet_01v8_lvt  IS MISSING !!!!
*  M23 -  nfet_01v8  IS MISSING !!!!
*  M16 -  nfet_01v8  IS MISSING !!!!
*  x1 -  passgate  IS MISSING !!!!
*  x2 -  passgate  IS MISSING !!!!
*  x3 -  passgate  IS MISSING !!!!
*  p5 -  lab_pin  IS MISSING !!!!
*  p6 -  lab_pin  IS MISSING !!!!
*  p7 -  lab_pin  IS MISSING !!!!
*  l14 -  lab_pin  IS MISSING !!!!
*  C8 -  parax_cap  IS MISSING !!!!
*  C9 -  parax_cap  IS MISSING !!!!
*  C10 -  parax_cap  IS MISSING !!!!
*  l15 -  lab_pin  IS MISSING !!!!
*  p1 -  lab_pin  IS MISSING !!!!
*  M22 -  nfet_01v8_lvt  IS MISSING !!!!
*  p2 -  lab_pin  IS MISSING !!!!
*  l16 -  lab_pin  IS MISSING !!!!
*  p8 -  lab_pin  IS MISSING !!!!
*  M25 -  nfet_01v8_lvt  IS MISSING !!!!
*  p27 -  lab_pin  IS MISSING !!!!
*  p28 -  lab_pin  IS MISSING !!!!
*  M26 -  pfet_01v8_lvt  IS MISSING !!!!
*  p29 -  lab_pin  IS MISSING !!!!
*  l21 -  lab_pin  IS MISSING !!!!
*  l22 -  lab_pin  IS MISSING !!!!
*  C5 -  cap_mim_m3_1  IS MISSING !!!!
*  C2 -  cap_mim_m3_1  IS MISSING !!!!
*  C4 -  cap_mim_m3_1  IS MISSING !!!!
*  M3 -  nfet_01v8_lvt  IS MISSING !!!!
*  M13 -  pfet_01v8_lvt  IS MISSING !!!!
*  M7 -  nfet_01v8_lvt  IS MISSING !!!!
*  M12 -  pfet_01v8_lvt  IS MISSING !!!!
*  M2 -  nfet_01v8_lvt  IS MISSING !!!!
*  M14 -  pfet_01v8_lvt  IS MISSING !!!!
*  p30 -  lab_pin  IS MISSING !!!!
*  M27 -  pfet_01v8_lvt  IS MISSING !!!!
*  p31 -  lab_pin  IS MISSING !!!!
*  l17 -  lab_pin  IS MISSING !!!!
*  vpdiff -  ammeter  IS MISSING !!!!
*  VVSS -  vsource  IS MISSING !!!!
*  p3 -  lab_pin  IS MISSING !!!!
*  p4 -  lab_pin  IS MISSING !!!!
*  R1 -  res  IS MISSING !!!!
*  C6 -  parax_cap  IS MISSING !!!!
*  VVCC -  vsource  IS MISSING !!!!
*  p32 -  lab_pin  IS MISSING !!!!
*  p33 -  lab_pin  IS MISSING !!!!
*  R2 -  res  IS MISSING !!!!
*  C11 -  parax_cap  IS MISSING !!!!
*  VPLUS -  vsource  IS MISSING !!!!
*  p34 -  lab_pin  IS MISSING !!!!
*  p35 -  lab_pin  IS MISSING !!!!
*  VMINUS -  vsource  IS MISSING !!!!
*  p36 -  lab_pin  IS MISSING !!!!
*  p37 -  lab_pin  IS MISSING !!!!
*  VCAL -  vsource  IS MISSING !!!!
*  p38 -  lab_pin  IS MISSING !!!!
*  p39 -  lab_pin  IS MISSING !!!!
*  VEN -  vsource  IS MISSING !!!!
*  p40 -  lab_pin  IS MISSING !!!!
*  p41 -  lab_pin  IS MISSING !!!!
*  STIMULI -  code  IS MISSING !!!!
*  CORNER -  corner  IS MISSING !!!!
*  E5 -  vsource_arith  IS MISSING !!!!
*  p113 -  lab_pin  IS MISSING !!!!
*  p114 -  lab_pin  IS MISSING !!!!
*  l12 -  noconn  IS MISSING !!!!
*  lx -  title  IS MISSING !!!!
*  v2 -  ammeter  IS MISSING !!!!
*  l21 -  lab_wire  IS MISSING !!!!
*  h2 -  launcher  IS MISSING !!!!
.ends
