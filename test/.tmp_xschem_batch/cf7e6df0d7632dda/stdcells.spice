** sch_path: /home/omare/Documents/UWASIC/Schemify/test/examples/xschem_sky130/sky130_tests/stdcells.sch
.subckt stdcells QLATCH A X B Y CLK Q RESET_B XSCHEM VCC VSS

*  p1 -  lab_pin  IS MISSING !!!!
*  p2 -  lab_pin  IS MISSING !!!!
*  x1 -  nand2_1  IS MISSING !!!!
*  C1 -  parax_cap  IS MISSING !!!!
*  x2 -  dfrtp_1  IS MISSING !!!!
*  p10 -  lab_pin  IS MISSING !!!!
*  p11 -  lab_pin  IS MISSING !!!!
*  p14 -  lab_pin  IS MISSING !!!!
*  l15 -  lab_wire  IS MISSING !!!!
*  C2 -  parax_cap  IS MISSING !!!!
*  p16 -  lab_pin  IS MISSING !!!!
*  p17 -  lab_pin  IS MISSING !!!!
*  p18 -  lab_pin  IS MISSING !!!!
*  C3 -  parax_cap  IS MISSING !!!!
*  x3 -  nor2b_1  IS MISSING !!!!
*  x4 -  dlrbn_1  IS MISSING !!!!
*  p19 -  lab_pin  IS MISSING !!!!
*  p20 -  lab_pin  IS MISSING !!!!
*  p21 -  lab_pin  IS MISSING !!!!
*  p22 -  lab_pin  IS MISSING !!!!
*  C4 -  parax_cap  IS MISSING !!!!
*  p24 -  lab_pin  IS MISSING !!!!
*  x5 -  nor2b_1  IS MISSING !!!!
*  x6 -  nand2_1  IS MISSING !!!!
*  x7 -  a31o_2  IS MISSING !!!!
*  p15 -  lab_pin  IS MISSING !!!!
*  l2 -  noconn  IS MISSING !!!!
*  l3 -  noconn  IS MISSING !!!!
*  x8 -  inv_2  IS MISSING !!!!
*  l1 -  title  IS MISSING !!!!
*  p1 -  ipin  IS MISSING !!!!
*  p2 -  ipin  IS MISSING !!!!
*  p3 -  ipin  IS MISSING !!!!
*  p4 -  ipin  IS MISSING !!!!
*  p1 -  opin  IS MISSING !!!!
*  p2 -  opin  IS MISSING !!!!
*  p3 -  opin  IS MISSING !!!!
*  p1 -  opin  IS MISSING !!!!
*  p1 -  opin  IS MISSING !!!!
*  p1 -  ipin  IS MISSING !!!!
*  p1 -  ipin  IS MISSING !!!!
*  l15 -  lab_wire  IS MISSING !!!!
*  p24 -  lab_pin  IS MISSING !!!!
*  x13 -  buf_2  IS MISSING !!!!
*  p18 -  lab_pin  IS MISSING !!!!
*  p24 -  lab_pin  IS MISSING !!!!
*  x9 -  buf_2  IS MISSING !!!!
*  p18 -  lab_pin  IS MISSING !!!!
*  p24 -  lab_pin  IS MISSING !!!!
*  x14 -  buf_2  IS MISSING !!!!
*  p18 -  lab_pin  IS MISSING !!!!
*  p24 -  lab_pin  IS MISSING !!!!
*  x15 -  buf_2  IS MISSING !!!!
*  p18 -  lab_pin  IS MISSING !!!!
*  p24 -  lab_pin  IS MISSING !!!!
*  x11 -  buf_2  IS MISSING !!!!
*  p18 -  lab_pin  IS MISSING !!!!
*  C5 -  parax_cap  IS MISSING !!!!
*  C6 -  parax_cap  IS MISSING !!!!
*  C7 -  parax_cap  IS MISSING !!!!
*  C8 -  parax_cap  IS MISSING !!!!
*  C9 -  parax_cap  IS MISSING !!!!
.ends
