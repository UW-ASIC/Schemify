** sch_path: /home/omare/Documents/UWASIC/Schemify/test/examples/xschem_sky130/mips_cpu/controller.sch
.subckt controller instr[31] instr[30] instr[29] instr[28] instr[27] instr[26] instr[25] instr[24] instr[23] instr[22] instr[21]
+ instr[20] instr[19] instr[18] instr[17] instr[16] instr[15] instr[14] instr[13] instr[12] instr[11] instr[10] instr[9] instr[8] instr[7]
+ instr[6] instr[5] instr[4] instr[3] instr[2] instr[1] instr[0] branch jump mem_to_reg mem_write reg_dst reg_write alucontrol[2]
+ alucontrol[1] alucontrol[0] alu_src

*  p1 -  ipin  IS MISSING !!!!
*  p4 -  opin  IS MISSING !!!!
*  l1 -  title  IS MISSING !!!!
*  p2 -  opin  IS MISSING !!!!
*  p3 -  opin  IS MISSING !!!!
*  p5 -  opin  IS MISSING !!!!
*  p6 -  opin  IS MISSING !!!!
*  p7 -  opin  IS MISSING !!!!
*  p8 -  opin  IS MISSING !!!!
*  p9 -  opin  IS MISSING !!!!
*  xmaindec_inst -  maindec  IS MISSING !!!!
*  p10 -  lab_pin  IS MISSING !!!!
*  p11 -  lab_pin  IS MISSING !!!!
*  p12 -  lab_pin  IS MISSING !!!!
*  p13 -  lab_pin  IS MISSING !!!!
*  p14 -  lab_pin  IS MISSING !!!!
*  p15 -  lab_pin  IS MISSING !!!!
*  p16 -  lab_pin  IS MISSING !!!!
*  p17 -  lab_pin  IS MISSING !!!!
*  xaludec_inst -  aludec  IS MISSING !!!!
*  p18 -  lab_pin  IS MISSING !!!!
*  p19 -  lab_pin  IS MISSING !!!!
*  l3 -  noconn  IS MISSING !!!!
*  l4 -  noconn  IS MISSING !!!!
*  l5 -  noconn  IS MISSING !!!!
*  l6 -  noconn  IS MISSING !!!!
*  l2 -  noconn  IS MISSING !!!!
*  l7 -  noconn  IS MISSING !!!!
*  l8 -  noconn  IS MISSING !!!!
*  l9 -  noconn  IS MISSING !!!!
*  l10 -  noconn  IS MISSING !!!!
.ends
