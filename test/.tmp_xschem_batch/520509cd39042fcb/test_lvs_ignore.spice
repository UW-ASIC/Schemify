** sch_path: /nix/store/qriw4afhakn3sqg2al06kdyr745hx86w-xschem-3.4.7/share/doc/xschem/examples/test_lvs_ignore.sch
.subckt test_lvs_ignore

V2 net1 GND 0
x5 net3 net1 inv_ngspice RUP=2000 RDOWN=1000
R1 VDD net2 100MEG m=1
C1 net2 GND 1p m=1
x2 STARTUP net2 inv_ngspice RUP=2000 RDOWN=1000
R2 VDD net1 100MEG m=1
* short x1 : STARTUP <--> STARTUP
.ends

* expanding   symbol:  inv_ngspice.sym # of pins=2
** sym_path: /nix/store/qriw4afhakn3sqg2al06kdyr745hx86w-xschem-3.4.7/share/doc/xschem/ngspice/inv_ngspice.sym
** sch_path: /nix/store/qriw4afhakn3sqg2al06kdyr745hx86w-xschem-3.4.7/share/doc/xschem/ngspice/inv_ngspice.sch
.subckt inv_ngspice Y A  RUP=2000 RDOWN=1000
*.PININFO A:I Y:O
B1 X1 0 V = 'VCC/2*(1-tanh((V(A1)-VCC/2)*100))' m=1
C1 A1 0 8f m=1
C2 Y1 0 8f m=1
V1 Y Y1 0
.save i(v1)
V2 A1 A 0
.save i(v2)
B2 X1 Y1 I = 'v(X1,Y1) > 0 ? v(X1,Y1) / RUP : v(X1,Y1) / RDOWN' m=1
.ends

.GLOBAL GND
.GLOBAL VDD
