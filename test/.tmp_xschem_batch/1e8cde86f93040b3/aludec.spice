** sch_path: /home/omare/Documents/UWASIC/Schemify/test/examples/xschem_sky130/mips_cpu/aludec.sch
.subckt aludec instr[31] instr[30] instr[29] instr[28] instr[27] instr[26] instr[25] instr[24] instr[23] instr[22] instr[21]
+ instr[20] instr[19] instr[18] instr[17] instr[16] instr[15] instr[14] instr[13] instr[12] instr[11] instr[10] instr[9] instr[8] instr[7]
+ instr[6] instr[5] instr[4] instr[3] instr[2] instr[1] instr[0] alucontrol[2] alucontrol[1] alucontrol[0]

*  p1 -  ipin  IS MISSING !!!!
*  p4 -  opin  IS MISSING !!!!
*  l1 -  title  IS MISSING !!!!
*  x1 -    IS MISSING !!!!
*  l5 -  noconn  IS MISSING !!!!
*  l6 -  noconn  IS MISSING !!!!
.ends
