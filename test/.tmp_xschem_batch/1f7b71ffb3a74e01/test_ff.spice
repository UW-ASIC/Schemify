** sch_path: /home/omare/Documents/UWASIC/Schemify/test/examples/xschem_sky130/sky130_tests/test_ff.sch
.subckt test_ff

*  l1 -  title  IS MISSING !!!!
*  x17 -  and2_1  IS MISSING !!!!
*  x16 -  dlrtp_1  IS MISSING !!!!
*  x21 -  lvtnot  IS MISSING !!!!
*  x22 -  lvtnot  IS MISSING !!!!
*  x15 -  inv_1  IS MISSING !!!!
*  x20 -  inv_1  IS MISSING !!!!
*  x18 -  dfrtp_1  IS MISSING !!!!
*  x23 -  lvtnot  IS MISSING !!!!
*  V1 -  vsource  IS MISSING !!!!
*  l4 -  gnd  IS MISSING !!!!
*  l5 -  lab_pin  IS MISSING !!!!
*  V2 -  vsource  IS MISSING !!!!
*  l6 -  gnd  IS MISSING !!!!
*  l7 -  lab_pin  IS MISSING !!!!
*  V3 -  vsource  IS MISSING !!!!
*  l8 -  gnd  IS MISSING !!!!
*  l9 -  vdd  IS MISSING !!!!
*  l10 -  lab_pin  IS MISSING !!!!
*  l11 -  lab_pin  IS MISSING !!!!
*  l12 -  lab_wire  IS MISSING !!!!
*  l13 -  lab_wire  IS MISSING !!!!
*  l14 -  lab_wire  IS MISSING !!!!
*  x5 -  nand2_1  IS MISSING !!!!
*  x6 -  nand3_1  IS MISSING !!!!
*  x7 -  nand3_1  IS MISSING !!!!
*  x8 -  nand3_1  IS MISSING !!!!
*  x9 -  nand3_1  IS MISSING !!!!
*  x10 -  nand2_1  IS MISSING !!!!
*  l15 -  lab_pin  IS MISSING !!!!
*  l16 -  lab_pin  IS MISSING !!!!
*  l17 -  lab_pin  IS MISSING !!!!
*  l18 -  lab_pin  IS MISSING !!!!
*  l19 -  lab_pin  IS MISSING !!!!
*  V4 -  vsource  IS MISSING !!!!
*  l20 -  gnd  IS MISSING !!!!
*  l21 -  lab_pin  IS MISSING !!!!
*  x11 -  xor2_1  IS MISSING !!!!
*  x13 -  dlrtn_1  IS MISSING !!!!
*  l22 -  lab_pin  IS MISSING !!!!
*  l23 -  lab_pin  IS MISSING !!!!
*  l24 -  lab_pin  IS MISSING !!!!
*  l25 -  lab_pin  IS MISSING !!!!
*  x12 -  nand2_1  IS MISSING !!!!
*  x3 -  lvtnot  IS MISSING !!!!
*  l3 -  lab_pin  IS MISSING !!!!
*  l31 -  lab_pin  IS MISSING !!!!
*  l28 -  lab_pin  IS MISSING !!!!
*  l29 -  lab_pin  IS MISSING !!!!
*  l30 -  lab_pin  IS MISSING !!!!
*  STIMULI -  code  IS MISSING !!!!
*  x1 -  srlatch  IS MISSING !!!!
*  x2 -  srlatch  IS MISSING !!!!
*  x4 -  lvtnot  IS MISSING !!!!
*  l26 -  lab_pin  IS MISSING !!!!
*  l27 -  lab_pin  IS MISSING !!!!
*  l2 -  lab_pin  IS MISSING !!!!
*  x14 -  dfrbp_1  IS MISSING !!!!
*  l32 -  lab_pin  IS MISSING !!!!
*  l33 -  lab_pin  IS MISSING !!!!
*  l34 -  lab_pin  IS MISSING !!!!
*  x19 -  lvtnot  IS MISSING !!!!
*  x24 -  lvtnot  IS MISSING !!!!
*  x25 -  dfxtp_1  IS MISSING !!!!
*  l35 -  lab_pin  IS MISSING !!!!
*  l36 -  lab_pin  IS MISSING !!!!
*  x26 -  dlrbp_1  IS MISSING !!!!
*  l37 -  lab_pin  IS MISSING !!!!
*  l38 -  lab_pin  IS MISSING !!!!
*  l39 -  lab_pin  IS MISSING !!!!
*  l40 -  lab_pin  IS MISSING !!!!
*  l41 -  lab_pin  IS MISSING !!!!
?
.ends
