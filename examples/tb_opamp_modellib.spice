* ================================================
* Netlist: TB OpAmp Model Library
* Dialect: ngspice | Backend: ngspice
* Auto-generated by SchemifyRS — DO NOT EDIT above marker
* ================================================

* No netlist generated yet for: TB OpAmp Model Library

* ===== USER STIMULUS (edit below this line) =====

* Testbench with model library references
* Demonstrates .lib, .include, and .model usage for PDK integration

* ---- Model library includes ----
* Uncomment these for real PDK usage:
* .lib "/pdk/tsmc180/models/allmodels.lib" tt
* .include "/pdk/tsmc180/models/nmos_1v8.mod"
* .include "/pdk/tsmc180/models/pmos_1v8.mod"
* .include "/pdk/tsmc180/models/res_poly.mod"

* ---- Inline models (standalone demo) ----
* NMOS: typical 180nm low-voltage
.model nmos_1v8 nmos level=49 version=3.3
+ tnom=27 toxe=4.1e-9 toxp=3.2e-9 toxm=4.1e-9
+ dtox=9e-10 epsrox=3.9 wint=5e-9 lint=0
+ vth0=0.50 k1=0.53 k2=-0.08 k3=80
+ dvt0=0 dvt1=0 dvt2=0
+ nlx=1.74e-7 w0=0 k3b=0.6
+ vsat=1.5e5 ua=-1.4e-9 ub=2.3e-18 uc=-4.6e-11
+ rdsw=200 prwb=0 prwg=0 wr=1
+ u0=300 a0=1.0 ags=0.2 a1=0 a2=1
+ b0=0 b1=0
+ voff=-0.1 nfactor=1.5 eta0=0.08 etab=-0.07
+ dsub=0.56 cit=0 cdsc=2.4e-4
+ pclm=1.3 pdiblc1=0.39 pdiblc2=0.008
+ pdiblcb=-0.1 drout=0.56 pscbe1=4.24e8
+ pscbe2=1e-5 pvag=0.1 delta=0.01
+ alpha0=0 beta0=30

* PMOS: typical 180nm low-voltage
.model pmos_1v8 pmos level=49 version=3.3
+ tnom=27 toxe=4.1e-9 toxp=3.2e-9 toxm=4.1e-9
+ dtox=9e-10 epsrox=3.9 wint=5e-9 lint=0
+ vth0=-0.42 k1=0.55 k2=-0.09 k3=80
+ dvt0=0 dvt1=0 dvt2=0
+ nlx=1.74e-7 w0=0 k3b=0.6
+ vsat=1.2e5 ua=-1.2e-9 ub=2.1e-18 uc=-4.6e-11
+ rdsw=300 prwb=0 prwg=0 wr=1
+ u0=100 a0=1.0 ags=0.2 a1=0 a2=1
+ voff=-0.1 nfactor=1.5 eta0=0.08 etab=-0.07
+ dsub=0.56 cit=0 cdsc=2.4e-4
+ pclm=1.3 pdiblc1=0.39 pdiblc2=0.008

* ---- Two-stage opamp subcircuit ----
.subckt two_stage_opamp inp inn vout vdd vss
  * Diff pair
  M1 n1 inp tail vss nmos_1v8 W=10u L=500n M=1
  M2 n2 inn tail vss nmos_1v8 W=10u L=500n M=1
  * Active load (current mirror)
  M3 n1 n1 vdd vdd pmos_1v8 W=20u L=500n M=1
  M4 n2 n1 vdd vdd pmos_1v8 W=20u L=500n M=1
  * Tail current
  Itail vss tail 100u
  * Second stage
  M5 vout n2 vss vss nmos_1v8 W=40u L=180n M=1
  * Compensation
  Cc n2 vout 2p
  * Load
  Iload vdd vout 500u
.ends

* ---- Testbench ----
Xdut inp inn vout vdd 0 two_stage_opamp
Vdd vdd 0 1.8
Vinp inp 0 DC 0.9 AC 0.5
Vinn inn 0 0.9
Cload vout 0 5p

* ---- Analyses ----

* Open-loop DC sweep
.dc Vinp 0 1.8 1m

* Open-loop AC (gain & phase margin)
.ac dec 100 1 10G

* Transient step response
.tran 1n 10u

.save V(vout) V(inp) V(inn) V(n1) V(n2) I(Vdd)

* ---- Measurements ----
.meas dc vos FIND V(inp) WHEN V(vout)=0.9
.meas ac gain_db MAX vdb(vout)
.meas ac ugf WHEN vdb(vout)=0 RISE=1
.meas ac phase_margin FIND vp(vout) AT=ugf

.end
