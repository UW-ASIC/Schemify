* ================================================
* Netlist: TB RC Parametric Step
* Dialect: ngspice | Backend: ngspice
* Auto-generated by SchemifyRS — DO NOT EDIT above marker
* ================================================

* No netlist generated yet for: TB RC Parametric Step

* ===== USER STIMULUS (edit below this line) =====

* Parametric testbench with step_params
* Sweeps R and C values to explore RC time constant space

.param r_val = 1k
.param c_val = 100n

R1 in out {r_val}
C1 out 0 {c_val}
Vin in 0 PULSE(0 1 0 1n 1n 500u 1m)

* --- Step R: 500, 1k, 2k, 5k, 10k ---
.control
  let r_steps = 500 1k 2k 5k 10k
  foreach rv $&r_steps
    alter R1 = $rv
    tran 1u 3m
    meas tran t_rise TRIG V(out) VAL=0.1 RISE=1 TARG V(out) VAL=0.9 RISE=1
    meas tran t_fall TRIG V(out) VAL=0.9 FALL=1 TARG V(out) VAL=0.1 FALL=1
    echo "R=$rv  tau_rise=$&t_rise  tau_fall=$&t_fall"
  end
.endc

* --- Step C: 10n, 100n, 1u, 10u ---
.control
  let c_steps = 10n 100n 1u 10u
  foreach cv $&c_steps
    alter C1 = $cv
    tran 1u 3m
    meas tran t_rise TRIG V(out) VAL=0.1 RISE=1 TARG V(out) VAL=0.9 RISE=1
    echo "C=$cv  tau_rise=$&t_rise"
  end
.endc

* --- 2D sweep: R x C ---
.control
  let r_list = 1k 5k 10k
  let c_list = 100n 1u
  foreach rv $&r_list
    foreach cv $&c_list
      alter R1 = $rv
      alter C1 = $cv
      tran 1u 5m
      meas tran tau TRIG V(out) VAL=0.1 RISE=1 TARG V(out) VAL=0.632 RISE=1
      echo "R=$rv C=$cv  tau=$&tau  (expected RC=$&{$rv*$cv})"
    end
  end
.endc

.end
