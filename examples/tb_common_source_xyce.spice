* ================================================
* Netlist: TB Common Source Xyce
* Dialect: xyce | Backend: xyce
* Auto-generated by SchemifyRS — DO NOT EDIT above marker
* ================================================

.subckt common_source vin vout
M1 vout vin 0 0 nmos W=10u L=180n
Rd vout vdd_int 2k
.ends

* ===== USER STIMULUS (edit below this line) =====

Xdut vin vout common_source
Vdd vdd_int 0 3.3
Vin vin 0 DC 0.65 AC 10m

* Xyce-specific analysis
.DC Vin 0 3.3 10m
.AC DEC 100 1 10G
.PRINT DC V(vout)
.PRINT AC VM(vout) VP(vout)
.end
