* ================================================
* Netlist: TB Voltage Divider
* Dialect: ngspice | Backend: ngspice
* Auto-generated by SchemifyRS — DO NOT EDIT above marker
* ================================================

* No netlist generated yet for: TB Voltage Divider

* ===== USER STIMULUS (edit below this line) =====

Xdut in out voltage_divider
Vin in 0 5
Rload out 0 10k

.op
.dc Vin 0 5 0.1
.save V(out) V(in)
.end
