* ================================================
* Netlist: TB Common Source Param Sweep
* Dialect: ngspice | Backend: ngspice
* Auto-generated by SchemifyRS — DO NOT EDIT above marker
* ================================================

* No netlist generated yet for: TB Common Source Param Sweep

* ===== USER STIMULUS (edit below this line) =====

* Parametric sweep / optimizer example
* Sweep drain resistor and transistor width to find optimal gain-BW

.param rd_val = 5k
.param w_val  = 10u

* MOSFET model (simplified)
.model nmos_1v8 nmos level=1 vto=0.5 kp=120u lambda=0.04

M1 vout vin 0 0 nmos_1v8 W={w_val} L=180n
Rd vdd vout {rd_val}
Vdd vdd 0 1.8
Vin vin 0 DC 0.65 AC 10m
Cload vout 0 1p

* --- DC bias check ---
.op

* --- AC for gain/bandwidth ---
.ac dec 100 1 10G

* --- Parameter sweep: Rd ---
* ngspice: use .step or loop
.control
  let rd_list = 2k 5k 10k 20k
  foreach rd $&rd_list
    alter Rd = $rd
    ac dec 100 1 10G
    meas ac gain_db MAX vdb(vout)
    meas ac f3db WHEN vdb(vout)=gain_db-3 RISE=1
    echo "Rd=$rd  gain=$&gain_db dB  f3dB=$&f3db Hz"
  end
.endc

* --- Parameter sweep: W ---
.control
  let w_list = 5u 10u 20u 50u
  foreach wval $&w_list
    alter @M1[W] = $wval
    ac dec 100 1 10G
    meas ac gain_db MAX vdb(vout)
    meas ac f3db WHEN vdb(vout)=gain_db-3 RISE=1
    echo "W=$wval  gain=$&gain_db dB  f3dB=$&f3db Hz"
  end
.endc

.end
