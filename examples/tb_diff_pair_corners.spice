* ================================================
* Netlist: TB Diff Pair Multi-Corner
* Dialect: ngspice | Backend: ngspice
* Auto-generated by SchemifyRS — DO NOT EDIT above marker
* ================================================

* No netlist generated yet for: TB Diff Pair Multi-Corner

* ===== USER STIMULUS (edit below this line) =====

* Multi-corner simulation: TT / FF / SS / SF / FS
* Each corner loads a different model library section

* --- Corner definitions (adjust paths to your PDK) ---
* .lib "/pdk/models/nmos_1v8.lib" tt
* .lib "/pdk/models/pmos_1v8.lib" tt

* Simplified inline models per corner for demonstration:

* ---- TT (typical-typical) ----
.model nmos_1v8_tt nmos level=1 vto=0.50 kp=120u lambda=0.04
* ---- FF (fast-fast) ----
.model nmos_1v8_ff nmos level=1 vto=0.45 kp=140u lambda=0.035
* ---- SS (slow-slow) ----
.model nmos_1v8_ss nmos level=1 vto=0.55 kp=100u lambda=0.045
* ---- SF (slow-n fast-p) ----
.model nmos_1v8_sf nmos level=1 vto=0.55 kp=100u lambda=0.045
* ---- FS (fast-n slow-p) ----
.model nmos_1v8_fs nmos level=1 vto=0.45 kp=140u lambda=0.035

* --- Diff pair circuit ---
.subckt diff_pair inp inn outp outn vdd
  Rd1 vdd outp 10k
  Rd2 vdd outn 10k
  M1 outp inp tail 0 nmos_1v8_tt W=10u L=180n
  M2 outn inn tail 0 nmos_1v8_tt W=10u L=180n
  Itail tail 0 100u
.ends

* --- Testbench ---
Xdut inp inn outp outn vdd diff_pair
Vdd vdd 0 1.8
Vinp inp 0 DC 0.9 AC 0.5
Vinn inn 0 DC 0.9 AC -0.5

* --- Run all corners ---
.control
  set corners = ( tt ff ss sf fs )
  set models  = ( nmos_1v8_tt nmos_1v8_ff nmos_1v8_ss nmos_1v8_sf nmos_1v8_fs )

  let corner_idx = 0
  foreach corner $corners
    let model = $models[$&corner_idx]
    altermod @M1[model] = $model
    altermod @M2[model] = $model

    op
    echo "Corner: $corner  Vout_p = $&V(outp)  Vout_n = $&V(outn)"

    ac dec 100 1 10G
    meas ac gain_db MAX vdb(outp,outn)
    meas ac f3db WHEN vdb(outp,outn)=gain_db-3 RISE=1
    echo "Corner: $corner  Gain = $&gain_db dB  BW = $&f3db Hz"

    let corner_idx = corner_idx + 1
  end
.endc

.end
