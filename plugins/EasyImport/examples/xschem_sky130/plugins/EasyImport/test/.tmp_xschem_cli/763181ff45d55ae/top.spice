** sch_path: /home/omare/Documents/UWASIC/Schemify/plugins/EasyImport/examples/xschem_sky130/plugins/EasyImport/examples/xschem_sky130/mips_cpu/top.sch
.subckt top

.ends
