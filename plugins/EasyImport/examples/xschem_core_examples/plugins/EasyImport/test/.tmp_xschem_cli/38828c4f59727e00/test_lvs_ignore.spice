** sch_path: /home/omare/Documents/UWASIC/Schemify/plugins/EasyImport/examples/xschem_core_examples/plugins/EasyImport/examples/xschem_core_examples/test_lvs_ignore.sch
.subckt test_lvs_ignore

.ends
