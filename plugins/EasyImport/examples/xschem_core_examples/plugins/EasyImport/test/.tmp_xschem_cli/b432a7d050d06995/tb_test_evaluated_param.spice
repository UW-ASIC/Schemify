** sch_path: /home/omare/Documents/UWASIC/Schemify/plugins/EasyImport/examples/xschem_core_examples/plugins/EasyImport/examples/xschem_core_examples/tb_test_evaluated_param.sch
.subckt tb_test_evaluated_param

.ends
