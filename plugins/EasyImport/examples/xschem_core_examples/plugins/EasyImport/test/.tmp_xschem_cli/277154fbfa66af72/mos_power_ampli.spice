** sch_path: /home/omare/Documents/UWASIC/Schemify/plugins/EasyImport/examples/xschem_core_examples/plugins/EasyImport/examples/xschem_core_examples/mos_power_ampli.sch
.subckt mos_power_ampli

.ends
