** sch_path: /home/omare/Documents/UWASIC/Schemify/plugins/EasyImport/examples/xschem_core_examples/plugins/EasyImport/examples/xschem_core_examples/mos_power_ampli_extracted.sch
.subckt mos_power_ampli_extracted

.ends
