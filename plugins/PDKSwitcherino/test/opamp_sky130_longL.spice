** 5-Transistor OTA — SkyWater 130nm (sky130A) — Long-channel variant
** Uses L=2u for diff pair/load (vs L=0.5u in the short-L version).
** This maps well across PDKs because both source and target L are
** deep in long-channel regime where gds scales predictably with L.
**
**         VDD
**          |
**     M3 --+-- M4
**     |         |
**  net1       vout
**     |         |
**     M1 --+-- M2
**          |
**         net3
**          |
**         M5
**          |
**         VSS

.subckt opamp vip vin vout vdd vss

** PMOS active load (current mirror)
XM3 net1 net1 vdd vdd sky130_fd_pr__pfet_01v8 W=8u L=2u nf=2
XM4 vout net1 vdd vdd sky130_fd_pr__pfet_01v8 W=8u L=2u nf=2

** NMOS differential pair
XM1 net1 vip net3 vss sky130_fd_pr__nfet_01v8 W=4u L=2u nf=1
XM2 vout vin net3 vss sky130_fd_pr__nfet_01v8 W=4u L=2u nf=1

** NMOS tail current source (gate tied to bias)
XM5 net3 vbias vss vss sky130_fd_pr__nfet_01v8 W=4u L=4u nf=1

** Simple self-bias: diode-connected NMOS mirrors tail current
XM6 vbias vbias vss vss sky130_fd_pr__nfet_01v8 W=4u L=4u nf=1
Ibias vdd vbias 20u

.ends opamp
