.title CMOS Comparator
.model nmos_1v8 nmos(level=1 kp=0.00012 vto=0.5)
.model pmos_1v8 pmos(level=1 kp=6e-05 vto=-0.5)
Vdd vdd 0 1.8
Vin vin 0 0 PULSE(0 1.8 0 0.00001 0.00001 0.000000001 0.00002)
Vref vref 0 900m
M1 n1 vin tail 0 nmos_1v8 W=5u L=180n
M2 n2 vref tail 0 nmos_1v8 W=5u L=180n
M3 n1 n1 vdd vdd pmos_1v8 W=2u L=180n
M4 n2 n1 vdd vdd pmos_1v8 W=2u L=180n
Itail 0 tail 50u
Mp5 vout n2 vdd vdd pmos_1v8 W=4u L=180n
Mn5 vout n2 0 0 nmos_1v8 W=2u L=180n
Mhyst tail vout hyst_src 0 nmos_1v8 W=500n L=500n
Ihyst 0 hyst_src 5u
.end
